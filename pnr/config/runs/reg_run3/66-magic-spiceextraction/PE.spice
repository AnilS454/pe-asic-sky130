* NGSPICE file created from PE.ext - technology: sky130A

* Black-box entry subcircuit for sky130_fd_sc_hd__tapvpwrvgnd_1 abstract view
.subckt sky130_fd_sc_hd__tapvpwrvgnd_1 VGND VPWR
.ends

* Black-box entry subcircuit for sky130_ef_sc_hd__decap_12 abstract view
.subckt sky130_ef_sc_hd__decap_12 VPWR VGND VPB VNB
.ends

* Black-box entry subcircuit for sky130_fd_sc_hd__fill_1 abstract view
.subckt sky130_fd_sc_hd__fill_1 VGND VNB VPB VPWR
.ends

* Black-box entry subcircuit for sky130_fd_sc_hd__dlymetal6s2s_1 abstract view
.subckt sky130_fd_sc_hd__dlymetal6s2s_1 A VGND VNB VPB VPWR X
.ends

* Black-box entry subcircuit for sky130_fd_sc_hd__o21ai_1 abstract view
.subckt sky130_fd_sc_hd__o21ai_1 A1 A2 B1 VGND VNB VPB VPWR Y
.ends

* Black-box entry subcircuit for sky130_fd_sc_hd__o2bb2ai_4 abstract view
.subckt sky130_fd_sc_hd__o2bb2ai_4 A1_N A2_N B1 B2 VGND VNB VPB VPWR Y
.ends

* Black-box entry subcircuit for sky130_fd_sc_hd__dfxtp_1 abstract view
.subckt sky130_fd_sc_hd__dfxtp_1 CLK D VGND VNB VPB VPWR Q
.ends

* Black-box entry subcircuit for sky130_fd_sc_hd__buf_8 abstract view
.subckt sky130_fd_sc_hd__buf_8 A VGND VNB VPB VPWR X
.ends

* Black-box entry subcircuit for sky130_fd_sc_hd__clkbuf_2 abstract view
.subckt sky130_fd_sc_hd__clkbuf_2 A VGND VNB VPB VPWR X
.ends

* Black-box entry subcircuit for sky130_fd_sc_hd__buf_4 abstract view
.subckt sky130_fd_sc_hd__buf_4 A VGND VNB VPB VPWR X
.ends

* Black-box entry subcircuit for sky130_fd_sc_hd__decap_3 abstract view
.subckt sky130_fd_sc_hd__decap_3 VGND VNB VPB VPWR
.ends

* Black-box entry subcircuit for sky130_fd_sc_hd__decap_6 abstract view
.subckt sky130_fd_sc_hd__decap_6 VGND VNB VPB VPWR
.ends

* Black-box entry subcircuit for sky130_fd_sc_hd__nand2_1 abstract view
.subckt sky130_fd_sc_hd__nand2_1 A B VGND VNB VPB VPWR Y
.ends

* Black-box entry subcircuit for sky130_fd_sc_hd__a211oi_2 abstract view
.subckt sky130_fd_sc_hd__a211oi_2 A1 A2 B1 C1 VGND VNB VPB VPWR Y
.ends

* Black-box entry subcircuit for sky130_fd_sc_hd__and3_1 abstract view
.subckt sky130_fd_sc_hd__and3_1 A B C VGND VNB VPB VPWR X
.ends

* Black-box entry subcircuit for sky130_fd_sc_hd__a22oi_4 abstract view
.subckt sky130_fd_sc_hd__a22oi_4 A1 A2 B1 B2 VGND VNB VPB VPWR Y
.ends

* Black-box entry subcircuit for sky130_fd_sc_hd__a22o_1 abstract view
.subckt sky130_fd_sc_hd__a22o_1 A1 A2 B1 B2 VGND VNB VPB VPWR X
.ends

* Black-box entry subcircuit for sky130_fd_sc_hd__decap_4 abstract view
.subckt sky130_fd_sc_hd__decap_4 VGND VNB VPB VPWR
.ends

* Black-box entry subcircuit for sky130_fd_sc_hd__fill_2 abstract view
.subckt sky130_fd_sc_hd__fill_2 VGND VNB VPB VPWR
.ends

* Black-box entry subcircuit for sky130_fd_sc_hd__a21o_1 abstract view
.subckt sky130_fd_sc_hd__a21o_1 A1 A2 B1 VGND VNB VPB VPWR X
.ends

* Black-box entry subcircuit for sky130_fd_sc_hd__and2_1 abstract view
.subckt sky130_fd_sc_hd__and2_1 A B VGND VNB VPB VPWR X
.ends

* Black-box entry subcircuit for sky130_fd_sc_hd__a21oi_1 abstract view
.subckt sky130_fd_sc_hd__a21oi_1 A1 A2 B1 VGND VNB VPB VPWR Y
.ends

* Black-box entry subcircuit for sky130_fd_sc_hd__o211ai_4 abstract view
.subckt sky130_fd_sc_hd__o211ai_4 A1 A2 B1 C1 VGND VNB VPB VPWR Y
.ends

* Black-box entry subcircuit for sky130_fd_sc_hd__decap_8 abstract view
.subckt sky130_fd_sc_hd__decap_8 VGND VNB VPB VPWR
.ends

* Black-box entry subcircuit for sky130_fd_sc_hd__a21oi_4 abstract view
.subckt sky130_fd_sc_hd__a21oi_4 A1 A2 B1 VGND VNB VPB VPWR Y
.ends

* Black-box entry subcircuit for sky130_fd_sc_hd__o21bai_2 abstract view
.subckt sky130_fd_sc_hd__o21bai_2 A1 A2 B1_N VGND VNB VPB VPWR Y
.ends

* Black-box entry subcircuit for sky130_fd_sc_hd__dlygate4sd1_1 abstract view
.subckt sky130_fd_sc_hd__dlygate4sd1_1 A VGND VNB VPB VPWR X
.ends

* Black-box entry subcircuit for sky130_fd_sc_hd__a41o_1 abstract view
.subckt sky130_fd_sc_hd__a41o_1 A1 A2 A3 A4 B1 VGND VNB VPB VPWR X
.ends

* Black-box entry subcircuit for sky130_fd_sc_hd__buf_2 abstract view
.subckt sky130_fd_sc_hd__buf_2 A VGND VNB VPB VPWR X
.ends

* Black-box entry subcircuit for sky130_fd_sc_hd__clkbuf_16 abstract view
.subckt sky130_fd_sc_hd__clkbuf_16 A VGND VNB VPB VPWR X
.ends

* Black-box entry subcircuit for sky130_fd_sc_hd__nand3_4 abstract view
.subckt sky130_fd_sc_hd__nand3_4 A B C VGND VNB VPB VPWR Y
.ends

* Black-box entry subcircuit for sky130_fd_sc_hd__clkbuf_4 abstract view
.subckt sky130_fd_sc_hd__clkbuf_4 A VGND VNB VPB VPWR X
.ends

* Black-box entry subcircuit for sky130_fd_sc_hd__nand4_4 abstract view
.subckt sky130_fd_sc_hd__nand4_4 A B C D VGND VNB VPB VPWR Y
.ends

* Black-box entry subcircuit for sky130_fd_sc_hd__o21ai_2 abstract view
.subckt sky130_fd_sc_hd__o21ai_2 A1 A2 B1 VGND VNB VPB VPWR Y
.ends

* Black-box entry subcircuit for sky130_fd_sc_hd__nand4_1 abstract view
.subckt sky130_fd_sc_hd__nand4_1 A B C D VGND VNB VPB VPWR Y
.ends

* Black-box entry subcircuit for sky130_fd_sc_hd__o211ai_2 abstract view
.subckt sky130_fd_sc_hd__o211ai_2 A1 A2 B1 C1 VGND VNB VPB VPWR Y
.ends

* Black-box entry subcircuit for sky130_fd_sc_hd__or2_1 abstract view
.subckt sky130_fd_sc_hd__or2_1 A B VGND VNB VPB VPWR X
.ends

* Black-box entry subcircuit for sky130_fd_sc_hd__o21a_1 abstract view
.subckt sky130_fd_sc_hd__o21a_1 A1 A2 B1 VGND VNB VPB VPWR X
.ends

* Black-box entry subcircuit for sky130_fd_sc_hd__o2111ai_4 abstract view
.subckt sky130_fd_sc_hd__o2111ai_4 A1 A2 B1 C1 D1 VGND VNB VPB VPWR Y
.ends

* Black-box entry subcircuit for sky130_fd_sc_hd__o211a_1 abstract view
.subckt sky130_fd_sc_hd__o211a_1 A1 A2 B1 C1 VGND VNB VPB VPWR X
.ends

* Black-box entry subcircuit for sky130_fd_sc_hd__dlymetal6s4s_1 abstract view
.subckt sky130_fd_sc_hd__dlymetal6s4s_1 A VGND VNB VPB VPWR X
.ends

* Black-box entry subcircuit for sky130_fd_sc_hd__buf_6 abstract view
.subckt sky130_fd_sc_hd__buf_6 A VGND VNB VPB VPWR X
.ends

* Black-box entry subcircuit for sky130_fd_sc_hd__nor2_1 abstract view
.subckt sky130_fd_sc_hd__nor2_1 A B VGND VNB VPB VPWR Y
.ends

* Black-box entry subcircuit for sky130_fd_sc_hd__a22o_2 abstract view
.subckt sky130_fd_sc_hd__a22o_2 A1 A2 B1 B2 VGND VNB VPB VPWR X
.ends

* Black-box entry subcircuit for sky130_fd_sc_hd__o22a_1 abstract view
.subckt sky130_fd_sc_hd__o22a_1 A1 A2 B1 B2 VGND VNB VPB VPWR X
.ends

* Black-box entry subcircuit for sky130_fd_sc_hd__a211o_1 abstract view
.subckt sky130_fd_sc_hd__a211o_1 A1 A2 B1 C1 VGND VNB VPB VPWR X
.ends

* Black-box entry subcircuit for sky130_fd_sc_hd__nor2_2 abstract view
.subckt sky130_fd_sc_hd__nor2_2 A B VGND VNB VPB VPWR Y
.ends

* Black-box entry subcircuit for sky130_fd_sc_hd__o21ai_4 abstract view
.subckt sky130_fd_sc_hd__o21ai_4 A1 A2 B1 VGND VNB VPB VPWR Y
.ends

* Black-box entry subcircuit for sky130_fd_sc_hd__a22oi_2 abstract view
.subckt sky130_fd_sc_hd__a22oi_2 A1 A2 B1 B2 VGND VNB VPB VPWR Y
.ends

* Black-box entry subcircuit for sky130_fd_sc_hd__a2111oi_1 abstract view
.subckt sky130_fd_sc_hd__a2111oi_1 A1 A2 B1 C1 D1 VGND VNB VPB VPWR Y
.ends

* Black-box entry subcircuit for sky130_fd_sc_hd__o211ai_1 abstract view
.subckt sky130_fd_sc_hd__o211ai_1 A1 A2 B1 C1 VGND VNB VPB VPWR Y
.ends

* Black-box entry subcircuit for sky130_fd_sc_hd__o221ai_4 abstract view
.subckt sky130_fd_sc_hd__o221ai_4 A1 A2 B1 B2 C1 VGND VNB VPB VPWR Y
.ends

* Black-box entry subcircuit for sky130_fd_sc_hd__nand3_1 abstract view
.subckt sky130_fd_sc_hd__nand3_1 A B C VGND VNB VPB VPWR Y
.ends

* Black-box entry subcircuit for sky130_fd_sc_hd__and4_1 abstract view
.subckt sky130_fd_sc_hd__and4_1 A B C D VGND VNB VPB VPWR X
.ends

* Black-box entry subcircuit for sky130_fd_sc_hd__nand2_2 abstract view
.subckt sky130_fd_sc_hd__nand2_2 A B VGND VNB VPB VPWR Y
.ends

* Black-box entry subcircuit for sky130_fd_sc_hd__o22ai_1 abstract view
.subckt sky130_fd_sc_hd__o22ai_1 A1 A2 B1 B2 VGND VNB VPB VPWR Y
.ends

* Black-box entry subcircuit for sky130_fd_sc_hd__clkinv_4 abstract view
.subckt sky130_fd_sc_hd__clkinv_4 A VGND VNB VPB VPWR Y
.ends

* Black-box entry subcircuit for sky130_fd_sc_hd__a22oi_1 abstract view
.subckt sky130_fd_sc_hd__a22oi_1 A1 A2 B1 B2 VGND VNB VPB VPWR Y
.ends

* Black-box entry subcircuit for sky130_fd_sc_hd__nand2_4 abstract view
.subckt sky130_fd_sc_hd__nand2_4 A B VGND VNB VPB VPWR Y
.ends

* Black-box entry subcircuit for sky130_fd_sc_hd__nand2b_1 abstract view
.subckt sky130_fd_sc_hd__nand2b_1 A_N B VGND VNB VPB VPWR Y
.ends

* Black-box entry subcircuit for sky130_fd_sc_hd__a22o_4 abstract view
.subckt sky130_fd_sc_hd__a22o_4 A1 A2 B1 B2 VGND VNB VPB VPWR X
.ends

* Black-box entry subcircuit for sky130_fd_sc_hd__inv_6 abstract view
.subckt sky130_fd_sc_hd__inv_6 A VGND VNB VPB VPWR Y
.ends

* Black-box entry subcircuit for sky130_fd_sc_hd__o22ai_4 abstract view
.subckt sky130_fd_sc_hd__o22ai_4 A1 A2 B1 B2 VGND VNB VPB VPWR Y
.ends

* Black-box entry subcircuit for sky130_fd_sc_hd__nand3_2 abstract view
.subckt sky130_fd_sc_hd__nand3_2 A B C VGND VNB VPB VPWR Y
.ends

* Black-box entry subcircuit for sky130_fd_sc_hd__and4_2 abstract view
.subckt sky130_fd_sc_hd__and4_2 A B C D VGND VNB VPB VPWR X
.ends

* Black-box entry subcircuit for sky130_fd_sc_hd__dfxtp_4 abstract view
.subckt sky130_fd_sc_hd__dfxtp_4 CLK D VGND VNB VPB VPWR Q
.ends

* Black-box entry subcircuit for sky130_fd_sc_hd__o2bb2ai_2 abstract view
.subckt sky130_fd_sc_hd__o2bb2ai_2 A1_N A2_N B1 B2 VGND VNB VPB VPWR Y
.ends

* Black-box entry subcircuit for sky130_fd_sc_hd__o2111a_1 abstract view
.subckt sky130_fd_sc_hd__o2111a_1 A1 A2 B1 C1 D1 VGND VNB VPB VPWR X
.ends

* Black-box entry subcircuit for sky130_fd_sc_hd__clkinv_2 abstract view
.subckt sky130_fd_sc_hd__clkinv_2 A VGND VNB VPB VPWR Y
.ends

* Black-box entry subcircuit for sky130_fd_sc_hd__o211a_4 abstract view
.subckt sky130_fd_sc_hd__o211a_4 A1 A2 B1 C1 VGND VNB VPB VPWR X
.ends

* Black-box entry subcircuit for sky130_fd_sc_hd__a2bb2oi_4 abstract view
.subckt sky130_fd_sc_hd__a2bb2oi_4 A1_N A2_N B1 B2 VGND VNB VPB VPWR Y
.ends

* Black-box entry subcircuit for sky130_fd_sc_hd__a31o_1 abstract view
.subckt sky130_fd_sc_hd__a31o_1 A1 A2 A3 B1 VGND VNB VPB VPWR X
.ends

* Black-box entry subcircuit for sky130_fd_sc_hd__o2bb2a_2 abstract view
.subckt sky130_fd_sc_hd__o2bb2a_2 A1_N A2_N B1 B2 VGND VNB VPB VPWR X
.ends

* Black-box entry subcircuit for sky130_fd_sc_hd__a21oi_2 abstract view
.subckt sky130_fd_sc_hd__a21oi_2 A1 A2 B1 VGND VNB VPB VPWR Y
.ends

* Black-box entry subcircuit for sky130_fd_sc_hd__o2111ai_1 abstract view
.subckt sky130_fd_sc_hd__o2111ai_1 A1 A2 B1 C1 D1 VGND VNB VPB VPWR Y
.ends

* Black-box entry subcircuit for sky130_fd_sc_hd__clkinvlp_4 abstract view
.subckt sky130_fd_sc_hd__clkinvlp_4 A VGND VNB VPB VPWR Y
.ends

* Black-box entry subcircuit for sky130_fd_sc_hd__inv_2 abstract view
.subckt sky130_fd_sc_hd__inv_2 A VGND VNB VPB VPWR Y
.ends

* Black-box entry subcircuit for sky130_fd_sc_hd__dfxtp_2 abstract view
.subckt sky130_fd_sc_hd__dfxtp_2 CLK D VGND VNB VPB VPWR Q
.ends

* Black-box entry subcircuit for sky130_fd_sc_hd__buf_12 abstract view
.subckt sky130_fd_sc_hd__buf_12 A VGND VNB VPB VPWR X
.ends

* Black-box entry subcircuit for sky130_fd_sc_hd__o311a_1 abstract view
.subckt sky130_fd_sc_hd__o311a_1 A1 A2 A3 B1 C1 VGND VNB VPB VPWR X
.ends

* Black-box entry subcircuit for sky130_fd_sc_hd__bufinv_16 abstract view
.subckt sky130_fd_sc_hd__bufinv_16 A VGND VNB VPB VPWR Y
.ends

* Black-box entry subcircuit for sky130_fd_sc_hd__a41o_4 abstract view
.subckt sky130_fd_sc_hd__a41o_4 A1 A2 A3 A4 B1 VGND VNB VPB VPWR X
.ends

* Black-box entry subcircuit for sky130_fd_sc_hd__and4b_1 abstract view
.subckt sky130_fd_sc_hd__and4b_1 A_N B C D VGND VNB VPB VPWR X
.ends

* Black-box entry subcircuit for sky130_fd_sc_hd__buf_1 abstract view
.subckt sky130_fd_sc_hd__buf_1 A VGND VNB VPB VPWR X
.ends

* Black-box entry subcircuit for sky130_fd_sc_hd__o31a_1 abstract view
.subckt sky130_fd_sc_hd__o31a_1 A1 A2 A3 B1 VGND VNB VPB VPWR X
.ends

* Black-box entry subcircuit for sky130_fd_sc_hd__nand4_2 abstract view
.subckt sky130_fd_sc_hd__nand4_2 A B C D VGND VNB VPB VPWR Y
.ends

* Black-box entry subcircuit for sky130_fd_sc_hd__or4b_1 abstract view
.subckt sky130_fd_sc_hd__or4b_1 A B C D_N VGND VNB VPB VPWR X
.ends

* Black-box entry subcircuit for sky130_fd_sc_hd__o21bai_4 abstract view
.subckt sky130_fd_sc_hd__o21bai_4 A1 A2 B1_N VGND VNB VPB VPWR Y
.ends

* Black-box entry subcircuit for sky130_fd_sc_hd__nand3b_1 abstract view
.subckt sky130_fd_sc_hd__nand3b_1 A_N B C VGND VNB VPB VPWR Y
.ends

* Black-box entry subcircuit for sky130_fd_sc_hd__nor3_1 abstract view
.subckt sky130_fd_sc_hd__nor3_1 A B C VGND VNB VPB VPWR Y
.ends

* Black-box entry subcircuit for sky130_fd_sc_hd__xor2_1 abstract view
.subckt sky130_fd_sc_hd__xor2_1 A B VGND VNB VPB VPWR X
.ends

* Black-box entry subcircuit for sky130_fd_sc_hd__a2bb2o_1 abstract view
.subckt sky130_fd_sc_hd__a2bb2o_1 A1_N A2_N B1 B2 VGND VNB VPB VPWR X
.ends

* Black-box entry subcircuit for sky130_fd_sc_hd__a31oi_2 abstract view
.subckt sky130_fd_sc_hd__a31oi_2 A1 A2 A3 B1 VGND VNB VPB VPWR Y
.ends

* Black-box entry subcircuit for sky130_fd_sc_hd__clkbuf_1 abstract view
.subckt sky130_fd_sc_hd__clkbuf_1 A VGND VNB VPB VPWR X
.ends

* Black-box entry subcircuit for sky130_fd_sc_hd__a311oi_1 abstract view
.subckt sky130_fd_sc_hd__a311oi_1 A1 A2 A3 B1 C1 VGND VNB VPB VPWR Y
.ends

* Black-box entry subcircuit for sky130_fd_sc_hd__a31oi_1 abstract view
.subckt sky130_fd_sc_hd__a31oi_1 A1 A2 A3 B1 VGND VNB VPB VPWR Y
.ends

* Black-box entry subcircuit for sky130_fd_sc_hd__a41oi_2 abstract view
.subckt sky130_fd_sc_hd__a41oi_2 A1 A2 A3 A4 B1 VGND VNB VPB VPWR Y
.ends

* Black-box entry subcircuit for sky130_fd_sc_hd__a311o_1 abstract view
.subckt sky130_fd_sc_hd__a311o_1 A1 A2 A3 B1 C1 VGND VNB VPB VPWR X
.ends

* Black-box entry subcircuit for sky130_fd_sc_hd__o22ai_2 abstract view
.subckt sky130_fd_sc_hd__o22ai_2 A1 A2 B1 B2 VGND VNB VPB VPWR Y
.ends

* Black-box entry subcircuit for sky130_fd_sc_hd__or4_4 abstract view
.subckt sky130_fd_sc_hd__or4_4 A B C D VGND VNB VPB VPWR X
.ends

* Black-box entry subcircuit for sky130_fd_sc_hd__a32oi_4 abstract view
.subckt sky130_fd_sc_hd__a32oi_4 A1 A2 A3 B1 B2 VGND VNB VPB VPWR Y
.ends

* Black-box entry subcircuit for sky130_fd_sc_hd__a21boi_4 abstract view
.subckt sky130_fd_sc_hd__a21boi_4 A1 A2 B1_N VGND VNB VPB VPWR Y
.ends

* Black-box entry subcircuit for sky130_fd_sc_hd__o32ai_2 abstract view
.subckt sky130_fd_sc_hd__o32ai_2 A1 A2 A3 B1 B2 VGND VNB VPB VPWR Y
.ends

* Black-box entry subcircuit for sky130_fd_sc_hd__o21a_4 abstract view
.subckt sky130_fd_sc_hd__o21a_4 A1 A2 B1 VGND VNB VPB VPWR X
.ends

* Black-box entry subcircuit for sky130_fd_sc_hd__o41ai_4 abstract view
.subckt sky130_fd_sc_hd__o41ai_4 A1 A2 A3 A4 B1 VGND VNB VPB VPWR Y
.ends

* Black-box entry subcircuit for sky130_fd_sc_hd__dlygate4sd3_1 abstract view
.subckt sky130_fd_sc_hd__dlygate4sd3_1 A VGND VNB VPB VPWR X
.ends

* Black-box entry subcircuit for sky130_fd_sc_hd__o2bb2ai_1 abstract view
.subckt sky130_fd_sc_hd__o2bb2ai_1 A1_N A2_N B1 B2 VGND VNB VPB VPWR Y
.ends

* Black-box entry subcircuit for sky130_fd_sc_hd__nand3b_4 abstract view
.subckt sky130_fd_sc_hd__nand3b_4 A_N B C VGND VNB VPB VPWR Y
.ends

* Black-box entry subcircuit for sky130_fd_sc_hd__or3_1 abstract view
.subckt sky130_fd_sc_hd__or3_1 A B C VGND VNB VPB VPWR X
.ends

* Black-box entry subcircuit for sky130_fd_sc_hd__o21bai_1 abstract view
.subckt sky130_fd_sc_hd__o21bai_1 A1 A2 B1_N VGND VNB VPB VPWR Y
.ends

* Black-box entry subcircuit for sky130_fd_sc_hd__a32o_1 abstract view
.subckt sky130_fd_sc_hd__a32o_1 A1 A2 A3 B1 B2 VGND VNB VPB VPWR X
.ends

* Black-box entry subcircuit for sky130_fd_sc_hd__o221a_1 abstract view
.subckt sky130_fd_sc_hd__o221a_1 A1 A2 B1 B2 C1 VGND VNB VPB VPWR X
.ends

* Black-box entry subcircuit for sky130_fd_sc_hd__a2bb2oi_1 abstract view
.subckt sky130_fd_sc_hd__a2bb2oi_1 A1_N A2_N B1 B2 VGND VNB VPB VPWR Y
.ends

* Black-box entry subcircuit for sky130_fd_sc_hd__o31ai_4 abstract view
.subckt sky130_fd_sc_hd__o31ai_4 A1 A2 A3 B1 VGND VNB VPB VPWR Y
.ends

* Black-box entry subcircuit for sky130_fd_sc_hd__and3_4 abstract view
.subckt sky130_fd_sc_hd__and3_4 A B C VGND VNB VPB VPWR X
.ends

* Black-box entry subcircuit for sky130_fd_sc_hd__a2bb2o_2 abstract view
.subckt sky130_fd_sc_hd__a2bb2o_2 A1_N A2_N B1 B2 VGND VNB VPB VPWR X
.ends

* Black-box entry subcircuit for sky130_fd_sc_hd__a32o_2 abstract view
.subckt sky130_fd_sc_hd__a32o_2 A1 A2 A3 B1 B2 VGND VNB VPB VPWR X
.ends

* Black-box entry subcircuit for sky130_fd_sc_hd__o2bb2a_1 abstract view
.subckt sky130_fd_sc_hd__o2bb2a_1 A1_N A2_N B1 B2 VGND VNB VPB VPWR X
.ends

* Black-box entry subcircuit for sky130_fd_sc_hd__or3_4 abstract view
.subckt sky130_fd_sc_hd__or3_4 A B C VGND VNB VPB VPWR X
.ends

* Black-box entry subcircuit for sky130_fd_sc_hd__a32oi_2 abstract view
.subckt sky130_fd_sc_hd__a32oi_2 A1 A2 A3 B1 B2 VGND VNB VPB VPWR Y
.ends

* Black-box entry subcircuit for sky130_fd_sc_hd__a221o_1 abstract view
.subckt sky130_fd_sc_hd__a221o_1 A1 A2 B1 B2 C1 VGND VNB VPB VPWR X
.ends

* Black-box entry subcircuit for sky130_fd_sc_hd__a2bb2oi_2 abstract view
.subckt sky130_fd_sc_hd__a2bb2oi_2 A1_N A2_N B1 B2 VGND VNB VPB VPWR Y
.ends

* Black-box entry subcircuit for sky130_fd_sc_hd__a41oi_1 abstract view
.subckt sky130_fd_sc_hd__a41oi_1 A1 A2 A3 A4 B1 VGND VNB VPB VPWR Y
.ends

* Black-box entry subcircuit for sky130_fd_sc_hd__and4_4 abstract view
.subckt sky130_fd_sc_hd__and4_4 A B C D VGND VNB VPB VPWR X
.ends

* Black-box entry subcircuit for sky130_fd_sc_hd__nand4b_1 abstract view
.subckt sky130_fd_sc_hd__nand4b_1 A_N B C D VGND VNB VPB VPWR Y
.ends

* Black-box entry subcircuit for sky130_fd_sc_hd__xnor2_1 abstract view
.subckt sky130_fd_sc_hd__xnor2_1 A B VGND VNB VPB VPWR Y
.ends

* Black-box entry subcircuit for sky130_fd_sc_hd__nor3b_1 abstract view
.subckt sky130_fd_sc_hd__nor3b_1 A B C_N VGND VNB VPB VPWR Y
.ends

* Black-box entry subcircuit for sky130_fd_sc_hd__nor4_1 abstract view
.subckt sky130_fd_sc_hd__nor4_1 A B C D VGND VNB VPB VPWR Y
.ends

* Black-box entry subcircuit for sky130_fd_sc_hd__a2bb2o_4 abstract view
.subckt sky130_fd_sc_hd__a2bb2o_4 A1_N A2_N B1 B2 VGND VNB VPB VPWR X
.ends

* Black-box entry subcircuit for sky130_fd_sc_hd__o41ai_1 abstract view
.subckt sky130_fd_sc_hd__o41ai_1 A1 A2 A3 A4 B1 VGND VNB VPB VPWR Y
.ends

* Black-box entry subcircuit for sky130_fd_sc_hd__diode_2 abstract view
.subckt sky130_fd_sc_hd__diode_2 DIODE VGND VNB VPB VPWR
.ends

* Black-box entry subcircuit for sky130_fd_sc_hd__a221oi_4 abstract view
.subckt sky130_fd_sc_hd__a221oi_4 A1 A2 B1 B2 C1 VGND VNB VPB VPWR Y
.ends

* Black-box entry subcircuit for sky130_fd_sc_hd__and2b_1 abstract view
.subckt sky130_fd_sc_hd__and2b_1 A_N B VGND VNB VPB VPWR X
.ends

.subckt PE VGND VPWR a_in[0] a_in[1] a_in[2] a_in[3] a_in[4] a_in[5] a_in[6] a_in[7]
+ a_out[0] a_out[1] a_out[2] a_out[3] a_out[4] a_out[5] a_out[6] a_out[7] b_in[0]
+ b_in[1] b_in[2] b_in[3] b_in[4] b_in[5] b_in[6] b_in[7] b_out[0] b_out[1] b_out[2]
+ b_out[3] b_out[4] b_out[5] b_out[6] b_out[7] clear_acc clk psum[0] psum[10] psum[11]
+ psum[12] psum[13] psum[14] psum[15] psum[16] psum[17] psum[18] psum[19] psum[1]
+ psum[20] psum[21] psum[22] psum[23] psum[24] psum[25] psum[26] psum[27] psum[28]
+ psum[29] psum[2] psum[30] psum[31] psum[3] psum[4] psum[5] psum[6] psum[7] psum[8]
+ psum[9] reset v_a_in v_a_out v_b_in v_b_out
XTAP_TAPCELL_ROW_52_404 VGND VPWR sky130_fd_sc_hd__tapvpwrvgnd_1
XFILLER_52_29 VPWR VGND VPWR VGND sky130_ef_sc_hd__decap_12
XFILLER_26_85 VGND VGND VPWR VPWR sky130_fd_sc_hd__fill_1
XFILLER_9_148 VGND VGND VPWR VPWR sky130_fd_sc_hd__fill_1
Xrebuffer7 net141 VGND VGND VPWR VPWR net142 sky130_fd_sc_hd__dlymetal6s2s_1
XFILLER_36_203 VGND VGND VPWR VPWR sky130_fd_sc_hd__fill_1
X_1270_ _0591_ _0593_ _0595_ VGND VGND VPWR VPWR _0597_ sky130_fd_sc_hd__o21ai_1
X_0985_ _0316_ _0315_ _0245_ _0274_ VGND VGND VPWR VPWR _0317_ sky130_fd_sc_hd__o2bb2ai_4
X_1399_ clknet_3_7__leaf_clk _0025_ VGND VGND VPWR VPWR net53 sky130_fd_sc_hd__dfxtp_1
Xfanout105 net106 VGND VGND VPWR VPWR net105 sky130_fd_sc_hd__buf_8
Xfanout127 net12 VGND VGND VPWR VPWR net127 sky130_fd_sc_hd__clkbuf_2
Xfanout116 net15 VGND VGND VPWR VPWR net116 sky130_fd_sc_hd__buf_4
XFILLER_42_228 VPWR VGND VPWR VGND sky130_ef_sc_hd__decap_12
XPHY_EDGE_ROW_19_Left_72 VGND VGND VPWR VPWR sky130_fd_sc_hd__decap_3
XFILLER_27_225 VPWR VGND VPWR VGND sky130_ef_sc_hd__decap_12
XFILLER_27_269 VGND VGND VPWR VPWR sky130_fd_sc_hd__decap_6
XFILLER_12_76 VGND VGND VPWR VPWR sky130_fd_sc_hd__fill_1
XTAP_TAPCELL_ROW_5_140 VGND VPWR sky130_fd_sc_hd__tapvpwrvgnd_1
X_0770_ _0138_ _0139_ VGND VGND VPWR VPWR _0140_ sky130_fd_sc_hd__nand2_1
XTAP_TAPCELL_ROW_11_175 VGND VPWR sky130_fd_sc_hd__tapvpwrvgnd_1
X_1322_ _0620_ _0618_ _0616_ _0645_ VGND VGND VPWR VPWR _0647_ sky130_fd_sc_hd__a211oi_2
X_1253_ _0576_ _0578_ _0579_ VGND VGND VPWR VPWR _0580_ sky130_fd_sc_hd__and3_1
X_1184_ _0321_ _0377_ _0447_ VGND VGND VPWR VPWR _0513_ sky130_fd_sc_hd__o21ai_1
XTAP_TAPCELL_ROW_19_220 VGND VPWR sky130_fd_sc_hd__tapvpwrvgnd_1
XFILLER_24_239 VPWR VGND VPWR VGND sky130_ef_sc_hd__decap_12
X_0968_ net133 net196 net155 net90 VGND VGND VPWR VPWR _0300_ sky130_fd_sc_hd__a22oi_4
X_0899_ net91 net111 net135 net132 VGND VGND VPWR VPWR _0235_ sky130_fd_sc_hd__a22o_1
XPHY_EDGE_ROW_4_Left_57 VGND VGND VPWR VPWR sky130_fd_sc_hd__decap_3
XFILLER_15_239 VGND VGND VPWR VPWR sky130_fd_sc_hd__decap_3
XFILLER_30_209 VGND VGND VPWR VPWR sky130_fd_sc_hd__decap_4
XFILLER_38_309 VGND VGND VPWR VPWR sky130_fd_sc_hd__fill_2
XFILLER_2_165 VPWR VGND VPWR VGND sky130_ef_sc_hd__decap_12
XFILLER_2_121 VPWR VGND VPWR VGND sky130_ef_sc_hd__decap_12
XFILLER_0_35 VGND VGND VPWR VPWR sky130_fd_sc_hd__decap_3
XFILLER_0_57 VGND VGND VPWR VPWR sky130_fd_sc_hd__fill_2
XTAP_TAPCELL_ROW_16_201 VGND VPWR sky130_fd_sc_hd__tapvpwrvgnd_1
X_0822_ _0185_ _0184_ _0070_ VGND VGND VPWR VPWR _0186_ sky130_fd_sc_hd__a21o_1
XFILLER_50_3 VPWR VGND VPWR VGND sky130_ef_sc_hd__decap_12
X_0753_ _0123_ _0124_ VGND VGND VPWR VPWR _0125_ sky130_fd_sc_hd__and2_1
X_1305_ _0629_ _0627_ _0630_ VGND VGND VPWR VPWR _0054_ sky130_fd_sc_hd__a21oi_1
XTAP_TAPCELL_ROW_39_326 VGND VPWR sky130_fd_sc_hd__tapvpwrvgnd_1
X_1236_ _0558_ _0560_ _0563_ VGND VGND VPWR VPWR _0564_ sky130_fd_sc_hd__o21ai_1
XTAP_TAPCELL_ROW_47_370 VGND VPWR sky130_fd_sc_hd__tapvpwrvgnd_1
XPHY_EDGE_ROW_46_Left_99 VGND VGND VPWR VPWR sky130_fd_sc_hd__decap_3
X_1098_ net182 _0424_ _0422_ _0426_ VGND VGND VPWR VPWR _0428_ sky130_fd_sc_hd__o211ai_4
X_1167_ _0488_ _0489_ net151 _0479_ VGND VGND VPWR VPWR _0496_ sky130_fd_sc_hd__o211ai_4
XFILLER_20_242 VGND VGND VPWR VPWR sky130_fd_sc_hd__decap_8
XFILLER_20_264 VGND VGND VPWR VPWR sky130_fd_sc_hd__fill_1
XTAP_TAPCELL_ROW_22_237 VGND VPWR sky130_fd_sc_hd__tapvpwrvgnd_1
XTAP_TAPCELL_ROW_30_281 VGND VPWR sky130_fd_sc_hd__tapvpwrvgnd_1
XFILLER_43_301 VGND VGND VPWR VPWR sky130_fd_sc_hd__fill_2
XFILLER_34_85 VGND VGND VPWR VPWR sky130_fd_sc_hd__fill_2
XFILLER_34_41 VPWR VGND VPWR VGND sky130_ef_sc_hd__decap_12
XFILLER_7_279 VGND VGND VPWR VPWR sky130_fd_sc_hd__fill_1
XFILLER_38_128 VGND VGND VPWR VPWR sky130_fd_sc_hd__fill_2
X_1021_ net344 _0348_ _0337_ net74 VGND VGND VPWR VPWR _0352_ sky130_fd_sc_hd__o211ai_4
X_0805_ _0157_ _0159_ _0163_ _0164_ VGND VGND VPWR VPWR _0171_ sky130_fd_sc_hd__a22o_1
X_0736_ _0106_ _0103_ _0104_ VGND VGND VPWR VPWR _0110_ sky130_fd_sc_hd__a21oi_4
XFILLER_39_19 VGND VGND VPWR VPWR sky130_fd_sc_hd__decap_4
XFILLER_44_109 VGND VGND VPWR VPWR sky130_fd_sc_hd__fill_2
X_1219_ _0537_ _0538_ _0546_ VGND VGND VPWR VPWR _0547_ sky130_fd_sc_hd__o21bai_2
XTAP_TAPCELL_ROW_50_387 VGND VPWR sky130_fd_sc_hd__tapvpwrvgnd_1
XFILLER_35_109 VGND VGND VPWR VPWR sky130_fd_sc_hd__decap_3
XPHY_EDGE_ROW_7_Left_60 VGND VGND VPWR VPWR sky130_fd_sc_hd__decap_3
XFILLER_3_293 VPWR VGND VPWR VGND sky130_ef_sc_hd__decap_12
Xrebuffer28 net98 VGND VGND VPWR VPWR net163 sky130_fd_sc_hd__dlygate4sd1_1
XFILLER_13_3 VPWR VGND VPWR VGND sky130_ef_sc_hd__decap_12
Xrebuffer39 _0427_ VGND VGND VPWR VPWR net174 sky130_fd_sc_hd__dlymetal6s2s_1
Xrebuffer17 _0477_ VGND VGND VPWR VPWR net152 sky130_fd_sc_hd__clkbuf_2
XFILLER_34_164 VPWR VGND VPWR VGND sky130_ef_sc_hd__decap_12
XFILLER_34_153 VGND VGND VPWR VPWR sky130_fd_sc_hd__decap_4
X_1004_ net92 net131 net97 net101 _0326_ VGND VGND VPWR VPWR _0335_ sky130_fd_sc_hd__a41o_1
XFILLER_19_194 VGND VGND VPWR VPWR sky130_fd_sc_hd__decap_3
X_0719_ product_reg\[2\] net59 VGND VGND VPWR VPWR _0095_ sky130_fd_sc_hd__nand2_1
XFILLER_15_21 VGND VGND VPWR VPWR sky130_fd_sc_hd__fill_1
XFILLER_25_164 VGND VGND VPWR VPWR sky130_fd_sc_hd__decap_4
XFILLER_31_31 VGND VGND VPWR VPWR sky130_fd_sc_hd__fill_1
Xoutput42 net42 VGND VGND VPWR VPWR psum[14] sky130_fd_sc_hd__buf_2
Xoutput53 net53 VGND VGND VPWR VPWR psum[24] sky130_fd_sc_hd__buf_2
Xoutput64 net64 VGND VGND VPWR VPWR psum[5] sky130_fd_sc_hd__buf_2
XPHY_EDGE_ROW_33_Left_86 VGND VGND VPWR VPWR sky130_fd_sc_hd__decap_3
Xoutput31 net31 VGND VGND VPWR VPWR b_out[2] sky130_fd_sc_hd__buf_2
XFILLER_16_197 VGND VGND VPWR VPWR sky130_fd_sc_hd__decap_4
XFILLER_31_101 VGND VGND VPWR VPWR sky130_fd_sc_hd__decap_8
XFILLER_31_167 VGND VGND VPWR VPWR sky130_fd_sc_hd__fill_1
XFILLER_39_223 VGND VGND VPWR VPWR sky130_fd_sc_hd__fill_1
XTAP_TAPCELL_ROW_52_405 VGND VPWR sky130_fd_sc_hd__tapvpwrvgnd_1
XFILLER_22_178 VGND VGND VPWR VPWR sky130_fd_sc_hd__fill_1
XFILLER_45_248 VGND VGND VPWR VPWR sky130_fd_sc_hd__decap_8
Xclkbuf_3_6__f_clk clknet_0_clk VGND VGND VPWR VPWR clknet_3_6__leaf_clk sky130_fd_sc_hd__clkbuf_16
XFILLER_13_123 VGND VGND VPWR VPWR sky130_fd_sc_hd__fill_2
XFILLER_42_85 VGND VGND VPWR VPWR sky130_fd_sc_hd__decap_6
XFILLER_42_41 VGND VGND VPWR VPWR sky130_fd_sc_hd__decap_4
Xrebuffer8 _0398_ VGND VGND VPWR VPWR net143 sky130_fd_sc_hd__dlygate4sd1_1
XFILLER_13_189 VGND VGND VPWR VPWR sky130_fd_sc_hd__decap_8
XFILLER_3_57 VPWR VGND VPWR VGND sky130_ef_sc_hd__decap_12
XTAP_TAPCELL_ROW_8_160 VGND VPWR sky130_fd_sc_hd__tapvpwrvgnd_1
X_0984_ _0311_ _0310_ _0288_ VGND VGND VPWR VPWR _0316_ sky130_fd_sc_hd__nand3_4
XFILLER_8_193 VGND VGND VPWR VPWR sky130_fd_sc_hd__decap_3
X_1398_ clknet_3_7__leaf_clk _0024_ VGND VGND VPWR VPWR net52 sky130_fd_sc_hd__dfxtp_1
Xfanout128 net11 VGND VGND VPWR VPWR net128 sky130_fd_sc_hd__clkbuf_4
Xfanout106 net4 VGND VGND VPWR VPWR net106 sky130_fd_sc_hd__buf_4
Xfanout117 net15 VGND VGND VPWR VPWR net117 sky130_fd_sc_hd__buf_2
XFILLER_27_237 VPWR VGND VPWR VGND sky130_ef_sc_hd__decap_12
XFILLER_33_218 VGND VGND VPWR VPWR sky130_fd_sc_hd__decap_6
XTAP_TAPCELL_ROW_5_141 VGND VPWR sky130_fd_sc_hd__tapvpwrvgnd_1
XTAP_TAPCELL_ROW_28_265 VGND VPWR sky130_fd_sc_hd__tapvpwrvgnd_1
XFILLER_41_240 VGND VGND VPWR VPWR sky130_fd_sc_hd__fill_1
XTAP_TAPCELL_ROW_11_176 VGND VPWR sky130_fd_sc_hd__tapvpwrvgnd_1
X_1321_ _0618_ _0620_ _0616_ VGND VGND VPWR VPWR _0646_ sky130_fd_sc_hd__a21oi_1
X_1252_ net125 net121 net96 net94 VGND VGND VPWR VPWR _0579_ sky130_fd_sc_hd__nand4_4
X_1183_ _0504_ _0510_ _0509_ VGND VGND VPWR VPWR _0512_ sky130_fd_sc_hd__o21ai_2
XFILLER_17_281 VPWR VGND VPWR VGND sky130_ef_sc_hd__decap_12
XPHY_EDGE_ROW_20_Left_73 VGND VGND VPWR VPWR sky130_fd_sc_hd__decap_3
XFILLER_24_229 VGND VGND VPWR VPWR sky130_fd_sc_hd__decap_3
X_0967_ net105 net129 VGND VGND VPWR VPWR _0299_ sky130_fd_sc_hd__nand2_1
XPHY_EDGE_ROW_12_Right_12 VGND VGND VPWR VPWR sky130_fd_sc_hd__decap_3
X_0898_ net91 net132 net111 net135 VGND VGND VPWR VPWR _0234_ sky130_fd_sc_hd__nand4_1
XTAP_TAPCELL_ROW_2_122 VGND VPWR sky130_fd_sc_hd__tapvpwrvgnd_1
XPHY_EDGE_ROW_21_Right_21 VGND VGND VPWR VPWR sky130_fd_sc_hd__decap_3
XFILLER_23_10 VGND VGND VPWR VPWR sky130_fd_sc_hd__fill_1
XFILLER_23_262 VGND VGND VPWR VPWR sky130_fd_sc_hd__fill_1
XFILLER_23_65 VGND VGND VPWR VPWR sky130_fd_sc_hd__decap_6
XPHY_EDGE_ROW_30_Right_30 VGND VGND VPWR VPWR sky130_fd_sc_hd__decap_3
XFILLER_2_177 VPWR VGND VPWR VGND sky130_ef_sc_hd__decap_12
XFILLER_2_133 VGND VGND VPWR VPWR sky130_fd_sc_hd__decap_6
XTAP_TAPCELL_ROW_16_202 VGND VPWR sky130_fd_sc_hd__tapvpwrvgnd_1
X_0821_ _0183_ _0182_ _0179_ _0180_ VGND VGND VPWR VPWR _0185_ sky130_fd_sc_hd__o211ai_2
X_0752_ product_reg\[6\] net65 VGND VGND VPWR VPWR _0124_ sky130_fd_sc_hd__or2_1
XFILLER_14_251 VGND VGND VPWR VPWR sky130_fd_sc_hd__fill_1
XFILLER_43_3 VPWR VGND VPWR VGND sky130_ef_sc_hd__decap_12
X_1304_ product_reg\[11\] net80 net83 VGND VGND VPWR VPWR _0630_ sky130_fd_sc_hd__o21ai_1
XTAP_TAPCELL_ROW_39_327 VGND VPWR sky130_fd_sc_hd__tapvpwrvgnd_1
XFILLER_37_310 VGND VGND VPWR VPWR sky130_fd_sc_hd__fill_1
X_1235_ _0512_ _0515_ _0511_ VGND VGND VPWR VPWR _0563_ sky130_fd_sc_hd__o21a_1
X_1166_ net157 _0479_ _0486_ _0487_ VGND VGND VPWR VPWR _0495_ sky130_fd_sc_hd__o2bb2ai_4
XTAP_TAPCELL_ROW_47_371 VGND VPWR sky130_fd_sc_hd__tapvpwrvgnd_1
X_1097_ net385 _0354_ _0421_ _0420_ VGND VGND VPWR VPWR _0427_ sky130_fd_sc_hd__a22oi_4
XFILLER_50_41 VPWR VGND VPWR VGND sky130_ef_sc_hd__decap_12
XFILLER_34_53 VPWR VGND VPWR VGND sky130_ef_sc_hd__decap_12
XFILLER_7_225 VPWR VGND VPWR VGND sky130_ef_sc_hd__decap_12
XFILLER_11_221 VGND VGND VPWR VPWR sky130_fd_sc_hd__decap_3
XFILLER_46_151 VGND VGND VPWR VPWR sky130_fd_sc_hd__decap_4
X_1020_ net74 _0337_ _0349_ VGND VGND VPWR VPWR _0351_ sky130_fd_sc_hd__a21o_1
X_0804_ product_reg\[11\] net39 _0164_ _0163_ _0159_ VGND VGND VPWR VPWR _0170_ sky130_fd_sc_hd__o2111ai_4
X_0735_ net78 net398 net86 _0109_ VGND VGND VPWR VPWR _0004_ sky130_fd_sc_hd__o211a_1
XFILLER_52_121 VGND VGND VPWR VPWR sky130_fd_sc_hd__fill_1
X_1149_ _0406_ _0424_ _0475_ VGND VGND VPWR VPWR _0478_ sky130_fd_sc_hd__a21oi_1
XFILLER_25_302 VGND VGND VPWR VPWR sky130_fd_sc_hd__fill_1
X_1218_ _0544_ _0545_ VGND VGND VPWR VPWR _0546_ sky130_fd_sc_hd__nand2_1
XFILLER_52_154 VGND VGND VPWR VPWR sky130_fd_sc_hd__decap_3
XTAP_TAPCELL_ROW_50_388 VGND VPWR sky130_fd_sc_hd__tapvpwrvgnd_1
XPHY_EDGE_ROW_51_Left_104 VGND VGND VPWR VPWR sky130_fd_sc_hd__decap_3
XFILLER_3_261 VPWR VGND VPWR VGND sky130_ef_sc_hd__decap_12
Xrebuffer29 net163 VGND VGND VPWR VPWR net164 sky130_fd_sc_hd__dlygate4sd1_1
X_1003_ net128 net102 _0328_ _0331_ VGND VGND VPWR VPWR _0334_ sky130_fd_sc_hd__a22o_1
Xrebuffer18 net100 VGND VGND VPWR VPWR net153 sky130_fd_sc_hd__dlygate4sd1_1
XFILLER_34_176 VGND VGND VPWR VPWR sky130_fd_sc_hd__fill_2
X_0718_ net78 net364 net84 _0094_ VGND VGND VPWR VPWR _0002_ sky130_fd_sc_hd__o211a_1
XPHY_EDGE_ROW_6_Right_6 VGND VGND VPWR VPWR sky130_fd_sc_hd__decap_3
XFILLER_13_305 VGND VGND VPWR VPWR sky130_fd_sc_hd__decap_6
XFILLER_15_66 VGND VGND VPWR VPWR sky130_fd_sc_hd__fill_1
XFILLER_25_110 VGND VGND VPWR VPWR sky130_fd_sc_hd__fill_2
XFILLER_15_88 VGND VGND VPWR VPWR sky130_fd_sc_hd__fill_1
Xoutput43 net43 VGND VGND VPWR VPWR psum[15] sky130_fd_sc_hd__buf_2
Xoutput54 net54 VGND VGND VPWR VPWR psum[25] sky130_fd_sc_hd__buf_2
Xoutput65 net65 VGND VGND VPWR VPWR psum[6] sky130_fd_sc_hd__buf_2
XFILLER_0_253 VPWR VGND VPWR VGND sky130_ef_sc_hd__decap_12
Xoutput32 net32 VGND VGND VPWR VPWR b_out[3] sky130_fd_sc_hd__buf_2
Xoutput21 net21 VGND VGND VPWR VPWR a_out[0] sky130_fd_sc_hd__buf_2
XFILLER_31_113 VGND VGND VPWR VPWR sky130_fd_sc_hd__decap_3
XTAP_TAPCELL_ROW_52_406 VGND VPWR sky130_fd_sc_hd__tapvpwrvgnd_1
Xrebuffer9 _0477_ VGND VGND VPWR VPWR net144 sky130_fd_sc_hd__dlymetal6s4s_1
XFILLER_3_69 VPWR VGND VPWR VGND sky130_ef_sc_hd__decap_12
X_0983_ _0312_ net387 _0313_ net378 VGND VGND VPWR VPWR _0315_ sky130_fd_sc_hd__o211ai_4
Xfanout129 net11 VGND VGND VPWR VPWR net129 sky130_fd_sc_hd__buf_4
Xfanout107 net109 VGND VGND VPWR VPWR net107 sky130_fd_sc_hd__buf_6
Xfanout118 net120 VGND VGND VPWR VPWR net118 sky130_fd_sc_hd__clkbuf_4
X_1397_ clknet_3_7__leaf_clk _0023_ VGND VGND VPWR VPWR net51 sky130_fd_sc_hd__dfxtp_1
XFILLER_27_249 VGND VGND VPWR VPWR sky130_fd_sc_hd__fill_1
XFILLER_6_109 VPWR VGND VPWR VGND sky130_ef_sc_hd__decap_12
XTAP_TAPCELL_ROW_5_142 VGND VPWR sky130_fd_sc_hd__tapvpwrvgnd_1
XFILLER_33_208 VGND VGND VPWR VPWR sky130_fd_sc_hd__fill_2
XFILLER_26_282 VGND VGND VPWR VPWR sky130_fd_sc_hd__decap_8
XTAP_TAPCELL_ROW_28_266 VGND VPWR sky130_fd_sc_hd__tapvpwrvgnd_1
X_1320_ _0643_ _0644_ VGND VGND VPWR VPWR _0645_ sky130_fd_sc_hd__nor2_1
X_1182_ _0435_ net136 _0507_ _0505_ _0508_ VGND VGND VPWR VPWR _0511_ sky130_fd_sc_hd__o2111ai_4
X_1251_ net121 net96 net94 net125 VGND VGND VPWR VPWR _0578_ sky130_fd_sc_hd__a22o_2
XFILLER_17_293 VPWR VGND VPWR VGND sky130_ef_sc_hd__decap_12
X_0897_ net402 net80 _0232_ _0233_ VGND VGND VPWR VPWR _0043_ sky130_fd_sc_hd__o22a_1
X_0966_ _0264_ _0265_ _0267_ VGND VGND VPWR VPWR _0298_ sky130_fd_sc_hd__o21a_1
XTAP_TAPCELL_ROW_2_123 VGND VPWR sky130_fd_sc_hd__tapvpwrvgnd_1
XFILLER_23_55 VGND VGND VPWR VPWR sky130_fd_sc_hd__fill_1
XFILLER_3_3 VPWR VGND VPWR VGND sky130_ef_sc_hd__decap_12
XFILLER_48_41 VGND VGND VPWR VPWR sky130_fd_sc_hd__decap_8
XFILLER_2_189 VGND VGND VPWR VPWR sky130_fd_sc_hd__decap_6
XFILLER_0_15 VPWR VGND VPWR VGND sky130_ef_sc_hd__decap_12
XFILLER_9_35 VGND VGND VPWR VPWR sky130_fd_sc_hd__fill_2
XTAP_TAPCELL_ROW_16_203 VGND VPWR sky130_fd_sc_hd__tapvpwrvgnd_1
X_0820_ _0179_ _0180_ _0182_ _0183_ VGND VGND VPWR VPWR _0184_ sky130_fd_sc_hd__a211o_1
X_0751_ product_reg\[6\] net65 VGND VGND VPWR VPWR _0123_ sky130_fd_sc_hd__nand2_1
X_1303_ _0603_ _0628_ _0085_ VGND VGND VPWR VPWR _0629_ sky130_fd_sc_hd__a21oi_1
XFILLER_52_303 VGND VGND VPWR VPWR sky130_fd_sc_hd__decap_4
XTAP_TAPCELL_ROW_47_372 VGND VPWR sky130_fd_sc_hd__tapvpwrvgnd_1
XTAP_TAPCELL_ROW_39_328 VGND VPWR sky130_fd_sc_hd__tapvpwrvgnd_1
X_1234_ _0560_ _0558_ VGND VGND VPWR VPWR _0562_ sky130_fd_sc_hd__nor2_2
X_1096_ _0337_ _0350_ _0338_ VGND VGND VPWR VPWR _0426_ sky130_fd_sc_hd__a21o_1
X_1165_ net185 net187 _0490_ VGND VGND VPWR VPWR _0494_ sky130_fd_sc_hd__a21oi_4
X_0949_ _0279_ _0280_ _0261_ VGND VGND VPWR VPWR _0282_ sky130_fd_sc_hd__a21o_1
XFILLER_34_10 VPWR VGND VPWR VGND sky130_ef_sc_hd__decap_12
XFILLER_50_53 VGND VGND VPWR VPWR sky130_fd_sc_hd__fill_1
XFILLER_34_65 VGND VGND VPWR VPWR sky130_fd_sc_hd__decap_8
XFILLER_7_237 VPWR VGND VPWR VGND sky130_ef_sc_hd__decap_12
XFILLER_11_233 VGND VGND VPWR VPWR sky130_fd_sc_hd__decap_6
XFILLER_46_185 VGND VGND VPWR VPWR sky130_fd_sc_hd__decap_8
XTAP_TAPCELL_ROW_36_309 VGND VPWR sky130_fd_sc_hd__tapvpwrvgnd_1
XTAP_TAPCELL_ROW_44_353 VGND VPWR sky130_fd_sc_hd__tapvpwrvgnd_1
X_0803_ product_reg\[9\] net68 _0168_ _0153_ VGND VGND VPWR VPWR _0169_ sky130_fd_sc_hd__o211ai_4
X_0734_ _0107_ _0108_ net78 VGND VGND VPWR VPWR _0109_ sky130_fd_sc_hd__o21ai_1
XFILLER_52_133 VGND VGND VPWR VPWR sky130_fd_sc_hd__decap_3
XFILLER_52_111 VGND VGND VPWR VPWR sky130_fd_sc_hd__fill_1
XFILLER_52_100 VGND VGND VPWR VPWR sky130_fd_sc_hd__fill_1
X_1148_ _0473_ _0472_ _0476_ VGND VGND VPWR VPWR _0477_ sky130_fd_sc_hd__o21ai_4
X_1079_ net126 net5 net123 net106 VGND VGND VPWR VPWR _0409_ sky130_fd_sc_hd__a22oi_4
X_1217_ _0542_ _0543_ net107 net114 VGND VGND VPWR VPWR _0545_ sky130_fd_sc_hd__nand4_1
XTAP_TAPCELL_ROW_50_389 VGND VPWR sky130_fd_sc_hd__tapvpwrvgnd_1
XFILLER_29_65 VGND VGND VPWR VPWR sky130_fd_sc_hd__fill_2
XFILLER_3_273 VGND VGND VPWR VPWR sky130_fd_sc_hd__decap_6
X_1002_ net169 _0330_ _0326_ VGND VGND VPWR VPWR _0333_ sky130_fd_sc_hd__o21bai_2
Xrebuffer19 net100 VGND VGND VPWR VPWR net154 sky130_fd_sc_hd__dlygate4sd1_1
XFILLER_19_152 VGND VGND VPWR VPWR sky130_fd_sc_hd__fill_1
XFILLER_19_163 VGND VGND VPWR VPWR sky130_fd_sc_hd__decap_4
X_0717_ _0092_ _0093_ net78 VGND VGND VPWR VPWR _0094_ sky130_fd_sc_hd__o21ai_1
XFILLER_25_177 VGND VGND VPWR VPWR sky130_fd_sc_hd__fill_2
XFILLER_31_55 VGND VGND VPWR VPWR sky130_fd_sc_hd__fill_1
XFILLER_31_77 VPWR VGND VPWR VGND sky130_ef_sc_hd__decap_12
Xoutput55 net55 VGND VGND VPWR VPWR psum[26] sky130_fd_sc_hd__buf_2
Xoutput66 net66 VGND VGND VPWR VPWR psum[7] sky130_fd_sc_hd__buf_2
Xoutput44 net44 VGND VGND VPWR VPWR psum[16] sky130_fd_sc_hd__buf_2
XFILLER_0_221 VGND VGND VPWR VPWR sky130_fd_sc_hd__decap_3
XFILLER_0_265 VPWR VGND VPWR VGND sky130_ef_sc_hd__decap_12
Xoutput33 net33 VGND VGND VPWR VPWR b_out[4] sky130_fd_sc_hd__buf_2
Xoutput22 net22 VGND VGND VPWR VPWR a_out[1] sky130_fd_sc_hd__buf_2
XFILLER_31_169 VGND VGND VPWR VPWR sky130_fd_sc_hd__decap_4
XTAP_TAPCELL_ROW_52_407 VGND VPWR sky130_fd_sc_hd__tapvpwrvgnd_1
XFILLER_22_158 VPWR VGND VPWR VGND sky130_ef_sc_hd__decap_12
XFILLER_10_309 VGND VGND VPWR VPWR sky130_fd_sc_hd__fill_2
XFILLER_26_66 VGND VGND VPWR VPWR sky130_fd_sc_hd__fill_1
XFILLER_13_158 VGND VGND VPWR VPWR sky130_fd_sc_hd__fill_1
XFILLER_3_15 VPWR VGND VPWR VGND sky130_ef_sc_hd__decap_12
X_0982_ _0308_ _0312_ _0287_ _0313_ VGND VGND VPWR VPWR _0314_ sky130_fd_sc_hd__o211a_1
Xfanout119 net120 VGND VGND VPWR VPWR net119 sky130_fd_sc_hd__buf_4
Xfanout108 net109 VGND VGND VPWR VPWR net108 sky130_fd_sc_hd__buf_6
X_1396_ clknet_3_7__leaf_clk _0022_ VGND VGND VPWR VPWR net50 sky130_fd_sc_hd__dfxtp_1
XFILLER_42_209 VGND VGND VPWR VPWR sky130_fd_sc_hd__fill_2
XFILLER_50_220 VGND VGND VPWR VPWR sky130_fd_sc_hd__fill_2
XFILLER_35_272 VGND VGND VPWR VPWR sky130_fd_sc_hd__fill_1
XFILLER_10_139 VGND VGND VPWR VPWR sky130_fd_sc_hd__fill_1
XFILLER_12_68 VGND VGND VPWR VPWR sky130_fd_sc_hd__decap_8
XTAP_TAPCELL_ROW_5_143 VGND VPWR sky130_fd_sc_hd__tapvpwrvgnd_1
XFILLER_41_231 VGND VGND VPWR VPWR sky130_fd_sc_hd__fill_1
XFILLER_37_65 VGND VGND VPWR VPWR sky130_fd_sc_hd__decap_3
XFILLER_18_239 VGND VGND VPWR VPWR sky130_fd_sc_hd__fill_1
XFILLER_26_261 VPWR VGND VPWR VGND sky130_ef_sc_hd__decap_12
XTAP_TAPCELL_ROW_28_267 VGND VPWR sky130_fd_sc_hd__tapvpwrvgnd_1
XFILLER_41_297 VGND VGND VPWR VPWR sky130_fd_sc_hd__fill_1
X_1181_ _0435_ net136 _0508_ _0507_ VGND VGND VPWR VPWR _0510_ sky130_fd_sc_hd__o211ai_2
X_1250_ net122 net161 net94 net125 VGND VGND VPWR VPWR _0577_ sky130_fd_sc_hd__a22oi_2
XFILLER_17_261 VPWR VGND VPWR VGND sky130_ef_sc_hd__decap_12
X_0965_ _0264_ _0265_ _0267_ VGND VGND VPWR VPWR _0297_ sky130_fd_sc_hd__o21ai_1
X_0896_ net90 net135 net85 VGND VGND VPWR VPWR _0233_ sky130_fd_sc_hd__and3_1
X_1379_ clknet_3_7__leaf_clk _0005_ VGND VGND VPWR VPWR net63 sky130_fd_sc_hd__dfxtp_1
XTAP_TAPCELL_ROW_2_124 VGND VPWR sky130_fd_sc_hd__tapvpwrvgnd_1
XFILLER_23_78 VGND VGND VPWR VPWR sky130_fd_sc_hd__decap_3
XFILLER_23_286 VGND VGND VPWR VPWR sky130_fd_sc_hd__decap_3
XFILLER_0_27 VGND VGND VPWR VPWR sky130_fd_sc_hd__fill_1
XFILLER_0_49 VGND VGND VPWR VPWR sky130_fd_sc_hd__decap_3
XFILLER_14_253 VPWR VGND VPWR VGND sky130_ef_sc_hd__decap_12
XTAP_TAPCELL_ROW_16_204 VGND VPWR sky130_fd_sc_hd__tapvpwrvgnd_1
X_0750_ _0070_ _0072_ net17 net18 _0122_ VGND VGND VPWR VPWR _0006_ sky130_fd_sc_hd__a2111oi_1
Xfanout90 net9 VGND VGND VPWR VPWR net90 sky130_fd_sc_hd__buf_4
X_1302_ _0599_ _0626_ VGND VGND VPWR VPWR _0628_ sky130_fd_sc_hd__nor2_1
X_1233_ net199 _0555_ _0556_ _0557_ VGND VGND VPWR VPWR _0561_ sky130_fd_sc_hd__nand4_4
XTAP_TAPCELL_ROW_47_373 VGND VPWR sky130_fd_sc_hd__tapvpwrvgnd_1
XTAP_TAPCELL_ROW_39_329 VGND VPWR sky130_fd_sc_hd__tapvpwrvgnd_1
X_1095_ _0413_ _0415_ _0406_ _0407_ VGND VGND VPWR VPWR _0425_ sky130_fd_sc_hd__o211ai_1
X_1164_ _0486_ _0487_ net138 _0475_ net148 VGND VGND VPWR VPWR _0493_ sky130_fd_sc_hd__o221ai_4
XFILLER_20_289 VGND VGND VPWR VPWR sky130_fd_sc_hd__decap_3
X_0948_ _0261_ _0279_ _0280_ VGND VGND VPWR VPWR _0281_ sky130_fd_sc_hd__nand3_1
X_0879_ _0196_ net57 net58 _0222_ VGND VGND VPWR VPWR _0228_ sky130_fd_sc_hd__nand4_4
XFILLER_47_109 VGND VGND VPWR VPWR sky130_fd_sc_hd__decap_3
XFILLER_34_22 VGND VGND VPWR VPWR sky130_fd_sc_hd__fill_2
XFILLER_7_249 VPWR VGND VPWR VGND sky130_ef_sc_hd__decap_12
XFILLER_46_197 VGND VGND VPWR VPWR sky130_fd_sc_hd__fill_1
X_0802_ _0151_ _0152_ _0157_ _0158_ VGND VGND VPWR VPWR _0168_ sky130_fd_sc_hd__and4_1
XTAP_TAPCELL_ROW_44_354 VGND VPWR sky130_fd_sc_hd__tapvpwrvgnd_1
X_0733_ _0103_ _0105_ _0106_ VGND VGND VPWR VPWR _0108_ sky130_fd_sc_hd__and3_1
X_1216_ net107 net114 _0542_ _0543_ VGND VGND VPWR VPWR _0544_ sky130_fd_sc_hd__a22o_1
XFILLER_1_81 VPWR VGND VPWR VGND sky130_ef_sc_hd__decap_12
X_1147_ _0419_ _0407_ _0405_ VGND VGND VPWR VPWR _0476_ sky130_fd_sc_hd__a21oi_4
X_1078_ net107 net118 VGND VGND VPWR VPWR _0408_ sky130_fd_sc_hd__nand2_2
XFILLER_20_79 VGND VGND VPWR VPWR sky130_fd_sc_hd__fill_1
XFILLER_29_33 VGND VGND VPWR VPWR sky130_fd_sc_hd__decap_6
XFILLER_45_65 VGND VGND VPWR VPWR sky130_fd_sc_hd__decap_6
XFILLER_28_164 VGND VGND VPWR VPWR sky130_fd_sc_hd__fill_2
XFILLER_45_76 VGND VGND VPWR VPWR sky130_fd_sc_hd__decap_4
XFILLER_43_156 VGND VGND VPWR VPWR sky130_fd_sc_hd__decap_4
XFILLER_6_15 VPWR VGND VPWR VGND sky130_ef_sc_hd__decap_12
X_1001_ _0074_ _0076_ _0328_ _0331_ VGND VGND VPWR VPWR _0332_ sky130_fd_sc_hd__o211ai_4
XFILLER_19_186 VGND VGND VPWR VPWR sky130_fd_sc_hd__decap_8
X_0716_ _0090_ _0091_ product_reg\[0\] net37 VGND VGND VPWR VPWR _0093_ sky130_fd_sc_hd__and4_1
XFILLER_40_159 VGND VGND VPWR VPWR sky130_fd_sc_hd__fill_1
Xoutput23 net23 VGND VGND VPWR VPWR a_out[2] sky130_fd_sc_hd__buf_2
Xoutput34 net34 VGND VGND VPWR VPWR b_out[5] sky130_fd_sc_hd__buf_2
XFILLER_31_89 VPWR VGND VPWR VGND sky130_ef_sc_hd__decap_12
Xoutput45 net45 VGND VGND VPWR VPWR psum[17] sky130_fd_sc_hd__buf_2
Xoutput67 net67 VGND VGND VPWR VPWR psum[8] sky130_fd_sc_hd__buf_2
Xoutput56 net56 VGND VGND VPWR VPWR psum[27] sky130_fd_sc_hd__buf_2
XFILLER_0_277 VGND VGND VPWR VPWR sky130_fd_sc_hd__decap_3
XFILLER_16_156 VGND VGND VPWR VPWR sky130_fd_sc_hd__fill_2
XFILLER_47_281 VGND VGND VPWR VPWR sky130_fd_sc_hd__decap_6
XFILLER_11_3 VPWR VGND VPWR VGND sky130_ef_sc_hd__decap_12
XFILLER_38_292 VGND VGND VPWR VPWR sky130_fd_sc_hd__decap_4
XFILLER_9_108 VGND VGND VPWR VPWR sky130_fd_sc_hd__decap_4
XFILLER_3_27 VPWR VGND VPWR VGND sky130_ef_sc_hd__decap_12
XPHY_EDGE_ROW_48_Left_101 VGND VGND VPWR VPWR sky130_fd_sc_hd__decap_3
XFILLER_36_207 VPWR VGND VPWR VGND sky130_ef_sc_hd__decap_12
XFILLER_29_270 VGND VGND VPWR VPWR sky130_fd_sc_hd__fill_2
X_0981_ net380 _0294_ _0308_ net377 VGND VGND VPWR VPWR _0313_ sky130_fd_sc_hd__o2bb2ai_4
XFILLER_8_185 VGND VGND VPWR VPWR sky130_fd_sc_hd__decap_8
X_1395_ clknet_3_7__leaf_clk _0021_ VGND VGND VPWR VPWR net49 sky130_fd_sc_hd__dfxtp_1
Xfanout109 net3 VGND VGND VPWR VPWR net109 sky130_fd_sc_hd__clkbuf_4
XFILLER_50_287 VGND VGND VPWR VPWR sky130_fd_sc_hd__decap_4
XFILLER_50_276 VGND VGND VPWR VPWR sky130_fd_sc_hd__decap_6
XFILLER_37_55 VGND VGND VPWR VPWR sky130_fd_sc_hd__fill_1
XFILLER_26_251 VGND VGND VPWR VPWR sky130_fd_sc_hd__fill_1
XFILLER_26_273 VGND VGND VPWR VPWR sky130_fd_sc_hd__fill_2
XTAP_TAPCELL_ROW_28_268 VGND VPWR sky130_fd_sc_hd__tapvpwrvgnd_1
XFILLER_5_111 VGND VGND VPWR VPWR sky130_fd_sc_hd__fill_1
XFILLER_17_273 VGND VGND VPWR VPWR sky130_fd_sc_hd__decap_6
X_1180_ _0439_ _0366_ _0504_ _0506_ net159 VGND VGND VPWR VPWR _0509_ sky130_fd_sc_hd__o221ai_4
XFILLER_32_221 VGND VGND VPWR VPWR sky130_fd_sc_hd__decap_6
X_0964_ _0264_ _0267_ VGND VGND VPWR VPWR _0296_ sky130_fd_sc_hd__nand2_2
X_0895_ net20 net19 net81 VGND VGND VPWR VPWR _0232_ sky130_fd_sc_hd__a21oi_4
X_1378_ clknet_3_7__leaf_clk _0004_ VGND VGND VPWR VPWR net62 sky130_fd_sc_hd__dfxtp_1
XTAP_TAPCELL_ROW_2_125 VGND VPWR sky130_fd_sc_hd__tapvpwrvgnd_1
XTAP_TAPCELL_ROW_25_249 VGND VPWR sky130_fd_sc_hd__tapvpwrvgnd_1
XTAP_TAPCELL_ROW_33_293 VGND VPWR sky130_fd_sc_hd__tapvpwrvgnd_1
Xfanout80 _0084_ VGND VGND VPWR VPWR net80 sky130_fd_sc_hd__clkbuf_4
XFILLER_9_15 VPWR VGND VPWR VGND sky130_ef_sc_hd__decap_12
XFILLER_14_265 VPWR VGND VPWR VGND sky130_ef_sc_hd__decap_12
Xfanout91 net9 VGND VGND VPWR VPWR net91 sky130_fd_sc_hd__clkbuf_2
XPHY_EDGE_ROW_24_Left_77 VGND VGND VPWR VPWR sky130_fd_sc_hd__decap_3
X_1301_ _0599_ net179 _0626_ VGND VGND VPWR VPWR _0627_ sky130_fd_sc_hd__o21ai_1
X_1232_ _0556_ _0555_ net200 _0557_ VGND VGND VPWR VPWR _0560_ sky130_fd_sc_hd__and4_1
XTAP_TAPCELL_ROW_47_374 VGND VPWR sky130_fd_sc_hd__tapvpwrvgnd_1
X_1094_ _0413_ _0415_ net146 VGND VGND VPWR VPWR _0424_ sky130_fd_sc_hd__o21ai_2
X_1163_ _0486_ _0487_ _0476_ _0475_ VGND VGND VPWR VPWR _0492_ sky130_fd_sc_hd__o22ai_1
X_0947_ _0272_ net384 _0277_ VGND VGND VPWR VPWR _0280_ sky130_fd_sc_hd__nand3_1
X_0878_ _0196_ net57 net58 _0222_ VGND VGND VPWR VPWR _0227_ sky130_fd_sc_hd__and4_1
XFILLER_11_202 VGND VGND VPWR VPWR sky130_fd_sc_hd__decap_6
XFILLER_11_213 VGND VGND VPWR VPWR sky130_fd_sc_hd__decap_8
Xclkload0 clknet_3_0__leaf_clk VGND VGND VPWR VPWR clkload0/Y sky130_fd_sc_hd__clkinv_4
XFILLER_11_279 VGND VGND VPWR VPWR sky130_fd_sc_hd__fill_1
XTAP_TAPCELL_ROW_21_230 VGND VPWR sky130_fd_sc_hd__tapvpwrvgnd_1
XTAP_TAPCELL_ROW_44_355 VGND VPWR sky130_fd_sc_hd__tapvpwrvgnd_1
X_0801_ product_reg\[11\] net39 _0166_ VGND VGND VPWR VPWR _0167_ sky130_fd_sc_hd__a21oi_1
X_0732_ _0105_ _0106_ _0103_ VGND VGND VPWR VPWR _0107_ sky130_fd_sc_hd__a21oi_1
X_1146_ _0467_ _0471_ _0474_ VGND VGND VPWR VPWR _0475_ sky130_fd_sc_hd__o21ai_4
X_1215_ _0073_ _0079_ _0451_ _0452_ _0454_ VGND VGND VPWR VPWR _0543_ sky130_fd_sc_hd__o221ai_4
XFILLER_52_113 VGND VGND VPWR VPWR sky130_fd_sc_hd__decap_8
XFILLER_1_93 VPWR VGND VPWR VGND sky130_ef_sc_hd__decap_12
X_1077_ _0401_ _0400_ _0394_ VGND VGND VPWR VPWR _0407_ sky130_fd_sc_hd__nand3_4
XFILLER_4_209 VPWR VGND VPWR VGND sky130_ef_sc_hd__decap_12
XFILLER_29_12 VGND VGND VPWR VPWR sky130_fd_sc_hd__decap_4
XFILLER_45_55 VGND VGND VPWR VPWR sky130_fd_sc_hd__fill_1
XFILLER_6_27 VGND VGND VPWR VPWR sky130_fd_sc_hd__fill_1
X_1000_ net92 net131 net97 net101 VGND VGND VPWR VPWR _0331_ sky130_fd_sc_hd__nand4_4
XFILLER_19_110 VGND VGND VPWR VPWR sky130_fd_sc_hd__fill_2
XFILLER_34_157 VGND VGND VPWR VPWR sky130_fd_sc_hd__fill_1
XFILLER_34_102 VGND VGND VPWR VPWR sky130_fd_sc_hd__fill_1
X_0715_ product_reg\[0\] net37 _0090_ _0091_ VGND VGND VPWR VPWR _0092_ sky130_fd_sc_hd__a22oi_1
XPHY_EDGE_ROW_27_Left_80 VGND VGND VPWR VPWR sky130_fd_sc_hd__decap_3
XPHY_EDGE_ROW_11_Left_64 VGND VGND VPWR VPWR sky130_fd_sc_hd__decap_3
X_1129_ _0452_ _0457_ VGND VGND VPWR VPWR _0458_ sky130_fd_sc_hd__nor2_2
XFILLER_15_25 VGND VGND VPWR VPWR sky130_fd_sc_hd__decap_4
Xoutput57 net57 VGND VGND VPWR VPWR psum[28] sky130_fd_sc_hd__buf_2
Xoutput35 net35 VGND VGND VPWR VPWR b_out[6] sky130_fd_sc_hd__buf_2
Xoutput46 net46 VGND VGND VPWR VPWR psum[18] sky130_fd_sc_hd__buf_2
Xoutput24 net24 VGND VGND VPWR VPWR a_out[3] sky130_fd_sc_hd__buf_2
XFILLER_31_57 VPWR VGND VPWR VGND sky130_ef_sc_hd__decap_12
Xoutput68 net68 VGND VGND VPWR VPWR psum[9] sky130_fd_sc_hd__buf_2
XFILLER_48_249 VGND VGND VPWR VPWR sky130_fd_sc_hd__decap_3
XFILLER_48_205 VGND VGND VPWR VPWR sky130_fd_sc_hd__decap_4
XFILLER_16_124 VPWR VGND VPWR VGND sky130_ef_sc_hd__decap_12
XPHY_EDGE_ROW_19_Right_19 VGND VGND VPWR VPWR sky130_fd_sc_hd__decap_3
Xclkbuf_3_1__f_clk clknet_0_clk VGND VGND VPWR VPWR clknet_3_1__leaf_clk sky130_fd_sc_hd__clkbuf_16
XFILLER_8_301 VGND VGND VPWR VPWR sky130_fd_sc_hd__decap_6
XPHY_EDGE_ROW_28_Right_28 VGND VGND VPWR VPWR sky130_fd_sc_hd__decap_3
XFILLER_47_260 VGND VGND VPWR VPWR sky130_fd_sc_hd__decap_6
XPHY_EDGE_ROW_37_Right_37 VGND VGND VPWR VPWR sky130_fd_sc_hd__decap_3
XFILLER_22_116 VGND VGND VPWR VPWR sky130_fd_sc_hd__fill_2
XPHY_EDGE_ROW_46_Right_46 VGND VGND VPWR VPWR sky130_fd_sc_hd__decap_3
XFILLER_26_35 VGND VGND VPWR VPWR sky130_fd_sc_hd__fill_2
XFILLER_26_46 VPWR VGND VPWR VGND sky130_ef_sc_hd__decap_12
XFILLER_42_45 VGND VGND VPWR VPWR sky130_fd_sc_hd__fill_1
XFILLER_21_193 VGND VGND VPWR VPWR sky130_fd_sc_hd__decap_4
XFILLER_3_39 VPWR VGND VPWR VGND sky130_ef_sc_hd__decap_12
XFILLER_36_219 VGND VGND VPWR VPWR sky130_fd_sc_hd__fill_2
XTAP_TAPCELL_ROW_14_188 VGND VPWR sky130_fd_sc_hd__tapvpwrvgnd_1
X_0980_ _0298_ _0306_ _0295_ VGND VGND VPWR VPWR _0312_ sky130_fd_sc_hd__a21o_1
XFILLER_8_197 VPWR VGND VPWR VGND sky130_ef_sc_hd__decap_12
X_1394_ clknet_3_7__leaf_clk _0020_ VGND VGND VPWR VPWR net47 sky130_fd_sc_hd__dfxtp_1
XFILLER_50_233 VGND VGND VPWR VPWR sky130_fd_sc_hd__fill_1
XFILLER_35_263 VGND VGND VPWR VPWR sky130_fd_sc_hd__fill_1
XFILLER_12_15 VPWR VGND VPWR VGND sky130_ef_sc_hd__decap_12
XFILLER_2_307 VGND VGND VPWR VPWR sky130_fd_sc_hd__fill_1
XFILLER_37_23 VPWR VGND VPWR VGND sky130_ef_sc_hd__decap_12
XFILLER_41_222 VGND VGND VPWR VPWR sky130_fd_sc_hd__fill_2
XTAP_TAPCELL_ROW_28_269 VGND VPWR sky130_fd_sc_hd__tapvpwrvgnd_1
XFILLER_5_167 VGND VGND VPWR VPWR sky130_fd_sc_hd__fill_1
Xrebuffer250 _0339_ VGND VGND VPWR VPWR net385 sky130_fd_sc_hd__buf_4
X_0894_ _0080_ net81 VGND VGND VPWR VPWR _0042_ sky130_fd_sc_hd__nor2_1
X_0963_ _0294_ _0293_ VGND VGND VPWR VPWR _0295_ sky130_fd_sc_hd__nand2_4
X_1377_ clknet_3_5__leaf_clk _0003_ VGND VGND VPWR VPWR net59 sky130_fd_sc_hd__dfxtp_1
XTAP_TAPCELL_ROW_2_126 VGND VPWR sky130_fd_sc_hd__tapvpwrvgnd_1
XTAP_TAPCELL_ROW_33_294 VGND VPWR sky130_fd_sc_hd__tapvpwrvgnd_1
XFILLER_48_88 VGND VGND VPWR VPWR sky130_fd_sc_hd__decap_4
XFILLER_14_222 VGND VGND VPWR VPWR sky130_fd_sc_hd__decap_4
Xfanout81 _0083_ VGND VGND VPWR VPWR net81 sky130_fd_sc_hd__buf_4
XFILLER_9_27 VGND VGND VPWR VPWR sky130_fd_sc_hd__decap_8
Xfanout92 net9 VGND VGND VPWR VPWR net92 sky130_fd_sc_hd__buf_4
XFILLER_14_277 VPWR VGND VPWR VGND sky130_ef_sc_hd__decap_12
X_1300_ _0624_ _0625_ VGND VGND VPWR VPWR _0626_ sky130_fd_sc_hd__nand2b_1
X_1231_ _0555_ _0556_ _0557_ _0498_ VGND VGND VPWR VPWR _0559_ sky130_fd_sc_hd__a22o_4
XFILLER_1_181 VPWR VGND VPWR VGND sky130_ef_sc_hd__decap_12
X_1162_ _0479_ net152 _0488_ _0489_ VGND VGND VPWR VPWR _0491_ sky130_fd_sc_hd__o2bb2ai_4
X_1093_ _0414_ _0416_ _0394_ _0404_ VGND VGND VPWR VPWR _0423_ sky130_fd_sc_hd__a22oi_2
X_0877_ net57 _0224_ _0225_ net87 VGND VGND VPWR VPWR _0029_ sky130_fd_sc_hd__o211a_1
XFILLER_9_281 VPWR VGND VPWR VGND sky130_ef_sc_hd__decap_12
X_0946_ _0272_ _0273_ _0277_ VGND VGND VPWR VPWR _0279_ sky130_fd_sc_hd__a21o_1
X_1429_ clknet_3_2__leaf_clk _0055_ VGND VGND VPWR VPWR product_reg\[12\] sky130_fd_sc_hd__dfxtp_1
XTAP_TAPCELL_ROW_38_320 VGND VPWR sky130_fd_sc_hd__tapvpwrvgnd_1
XPHY_EDGE_ROW_41_Left_94 VGND VGND VPWR VPWR sky130_fd_sc_hd__decap_3
Xclkload1 clknet_3_1__leaf_clk VGND VGND VPWR VPWR clkload1/Y sky130_fd_sc_hd__inv_6
XTAP_TAPCELL_ROW_21_231 VGND VPWR sky130_fd_sc_hd__tapvpwrvgnd_1
XFILLER_1_3 VPWR VGND VPWR VGND sky130_ef_sc_hd__decap_12
XTAP_TAPCELL_ROW_44_356 VGND VPWR sky130_fd_sc_hd__tapvpwrvgnd_1
X_0800_ _0157_ net38 product_reg\[10\] VGND VGND VPWR VPWR _0166_ sky130_fd_sc_hd__and3_1
X_0731_ product_reg\[3\] net62 VGND VGND VPWR VPWR _0106_ sky130_fd_sc_hd__or2_1
XFILLER_6_251 VGND VGND VPWR VPWR sky130_fd_sc_hd__fill_1
X_1145_ _0458_ net188 _0467_ _0469_ VGND VGND VPWR VPWR _0474_ sky130_fd_sc_hd__o22ai_4
X_1214_ _0540_ net116 net104 net260 VGND VGND VPWR VPWR _0542_ sky130_fd_sc_hd__nand4_1
XFILLER_52_169 VGND VGND VPWR VPWR sky130_fd_sc_hd__fill_1
XFILLER_52_147 VGND VGND VPWR VPWR sky130_fd_sc_hd__decap_3
XFILLER_40_309 VGND VGND VPWR VPWR sky130_fd_sc_hd__fill_2
X_1076_ _0403_ net191 _0393_ _0402_ VGND VGND VPWR VPWR _0406_ sky130_fd_sc_hd__o211ai_4
X_0929_ _0246_ _0248_ _0247_ VGND VGND VPWR VPWR _0262_ sky130_fd_sc_hd__o21ai_2
XFILLER_29_57 VGND VGND VPWR VPWR sky130_fd_sc_hd__decap_8
XFILLER_43_103 VGND VGND VPWR VPWR sky130_fd_sc_hd__decap_4
XFILLER_28_188 VGND VGND VPWR VPWR sky130_fd_sc_hd__fill_2
XTAP_TAPCELL_ROW_41_337 VGND VPWR sky130_fd_sc_hd__tapvpwrvgnd_1
XFILLER_22_309 VGND VGND VPWR VPWR sky130_fd_sc_hd__fill_2
X_0714_ net372 net359 VGND VGND VPWR VPWR _0091_ sky130_fd_sc_hd__nand2_1
XFILLER_15_15 VGND VGND VPWR VPWR sky130_fd_sc_hd__decap_6
X_1128_ _0454_ net120 net104 VGND VGND VPWR VPWR _0457_ sky130_fd_sc_hd__nand3_2
X_1059_ _0385_ _0386_ net134 net115 VGND VGND VPWR VPWR _0389_ sky130_fd_sc_hd__and4_2
XFILLER_25_169 VGND VGND VPWR VPWR sky130_fd_sc_hd__decap_8
XFILLER_31_47 VGND VGND VPWR VPWR sky130_fd_sc_hd__decap_8
Xoutput69 net69 VGND VGND VPWR VPWR v_a_out sky130_fd_sc_hd__buf_2
Xoutput58 net58 VGND VGND VPWR VPWR psum[29] sky130_fd_sc_hd__buf_2
Xoutput47 net47 VGND VGND VPWR VPWR psum[19] sky130_fd_sc_hd__buf_2
Xoutput36 net36 VGND VGND VPWR VPWR b_out[7] sky130_fd_sc_hd__buf_2
Xoutput25 net25 VGND VGND VPWR VPWR a_out[4] sky130_fd_sc_hd__buf_2
XFILLER_31_69 VGND VGND VPWR VPWR sky130_fd_sc_hd__decap_4
XFILLER_16_136 VGND VGND VPWR VPWR sky130_fd_sc_hd__decap_4
XFILLER_24_191 VGND VGND VPWR VPWR sky130_fd_sc_hd__fill_1
XFILLER_42_24 VGND VGND VPWR VPWR sky130_fd_sc_hd__decap_4
XFILLER_26_58 VGND VGND VPWR VPWR sky130_fd_sc_hd__decap_8
XFILLER_5_305 VGND VGND VPWR VPWR sky130_fd_sc_hd__decap_6
XFILLER_12_172 VGND VGND VPWR VPWR sky130_fd_sc_hd__fill_1
XTAP_TAPCELL_ROW_14_189 VGND VPWR sky130_fd_sc_hd__tapvpwrvgnd_1
X_1393_ clknet_3_7__leaf_clk _0019_ VGND VGND VPWR VPWR net46 sky130_fd_sc_hd__dfxtp_1
XFILLER_50_245 VGND VGND VPWR VPWR sky130_fd_sc_hd__decap_3
XFILLER_35_253 VGND VGND VPWR VPWR sky130_fd_sc_hd__decap_3
XFILLER_10_109 VGND VGND VPWR VPWR sky130_fd_sc_hd__decap_3
XFILLER_12_27 VGND VGND VPWR VPWR sky130_fd_sc_hd__fill_1
XFILLER_37_57 VGND VGND VPWR VPWR sky130_fd_sc_hd__decap_8
XFILLER_37_35 VPWR VGND VPWR VGND sky130_ef_sc_hd__decap_12
XFILLER_26_253 VGND VGND VPWR VPWR sky130_fd_sc_hd__decap_4
XFILLER_41_289 VGND VGND VPWR VPWR sky130_fd_sc_hd__fill_1
XFILLER_41_278 VGND VGND VPWR VPWR sky130_fd_sc_hd__fill_2
XFILLER_41_267 VGND VGND VPWR VPWR sky130_fd_sc_hd__decap_3
Xrebuffer240 product_reg\[1\] VGND VGND VPWR VPWR net375 sky130_fd_sc_hd__dlygate4sd1_1
XFILLER_5_113 VPWR VGND VPWR VGND sky130_ef_sc_hd__decap_12
Xrebuffer251 _0289_ VGND VGND VPWR VPWR net386 sky130_fd_sc_hd__dlygate4sd1_1
X_0893_ net164 net88 VGND VGND VPWR VPWR _0041_ sky130_fd_sc_hd__and2_1
X_0962_ _0292_ net119 net134 _0290_ VGND VGND VPWR VPWR _0294_ sky130_fd_sc_hd__nand4_4
XFILLER_4_83 VGND VGND VPWR VPWR sky130_fd_sc_hd__fill_1
XTAP_TAPCELL_ROW_10_170 VGND VPWR sky130_fd_sc_hd__tapvpwrvgnd_1
X_1376_ clknet_3_5__leaf_clk _0002_ VGND VGND VPWR VPWR net48 sky130_fd_sc_hd__dfxtp_4
XTAP_TAPCELL_ROW_2_127 VGND VPWR sky130_fd_sc_hd__tapvpwrvgnd_1
XTAP_TAPCELL_ROW_33_295 VGND VPWR sky130_fd_sc_hd__tapvpwrvgnd_1
XFILLER_23_223 VGND VGND VPWR VPWR sky130_fd_sc_hd__fill_1
XFILLER_23_278 VGND VGND VPWR VPWR sky130_fd_sc_hd__fill_2
Xfanout82 _0083_ VGND VGND VPWR VPWR net82 sky130_fd_sc_hd__clkbuf_2
Xfanout71 net72 VGND VGND VPWR VPWR net71 sky130_fd_sc_hd__buf_8
XFILLER_14_289 VPWR VGND VPWR VGND sky130_ef_sc_hd__decap_12
Xfanout93 net94 VGND VGND VPWR VPWR net93 sky130_fd_sc_hd__buf_8
XFILLER_52_307 VGND VGND VPWR VPWR sky130_fd_sc_hd__fill_1
X_1230_ _0555_ _0556_ _0557_ net200 VGND VGND VPWR VPWR _0558_ sky130_fd_sc_hd__a22oi_2
XFILLER_1_193 VPWR VGND VPWR VGND sky130_ef_sc_hd__decap_12
X_1092_ net158 net145 _0417_ _0418_ VGND VGND VPWR VPWR _0422_ sky130_fd_sc_hd__o2bb2ai_2
X_1161_ _0486_ _0487_ VGND VGND VPWR VPWR _0490_ sky130_fd_sc_hd__nor2_1
X_0876_ _0195_ _0182_ net57 _0193_ _0223_ VGND VGND VPWR VPWR _0226_ sky130_fd_sc_hd__o2111a_1
XFILLER_9_293 VPWR VGND VPWR VGND sky130_ef_sc_hd__decap_12
X_0945_ _0275_ _0276_ VGND VGND VPWR VPWR _0278_ sky130_fd_sc_hd__or2_1
XTAP_TAPCELL_ROW_30_276 VGND VPWR sky130_fd_sc_hd__tapvpwrvgnd_1
X_1428_ clknet_3_0__leaf_clk _0054_ VGND VGND VPWR VPWR product_reg\[11\] sky130_fd_sc_hd__dfxtp_1
XFILLER_18_26 VGND VGND VPWR VPWR sky130_fd_sc_hd__fill_2
X_1359_ _0673_ _0674_ _0681_ VGND VGND VPWR VPWR _0682_ sky130_fd_sc_hd__nand3_1
XTAP_TAPCELL_ROW_38_321 VGND VPWR sky130_fd_sc_hd__tapvpwrvgnd_1
Xclkload2 clknet_3_2__leaf_clk VGND VGND VPWR VPWR clkload2/Y sky130_fd_sc_hd__clkinv_2
XTAP_TAPCELL_ROW_44_357 VGND VPWR sky130_fd_sc_hd__tapvpwrvgnd_1
X_0730_ product_reg\[3\] net62 VGND VGND VPWR VPWR _0105_ sky130_fd_sc_hd__nand2_1
X_1213_ _0540_ net104 net262 net116 VGND VGND VPWR VPWR _0541_ sky130_fd_sc_hd__and4_1
XFILLER_52_126 VGND VGND VPWR VPWR sky130_fd_sc_hd__decap_3
X_1075_ net191 _0403_ _0393_ _0402_ VGND VGND VPWR VPWR _0405_ sky130_fd_sc_hd__o211a_4
XFILLER_1_51 VGND VGND VPWR VPWR sky130_fd_sc_hd__decap_4
X_1144_ net166 _0458_ _0468_ net180 VGND VGND VPWR VPWR _0473_ sky130_fd_sc_hd__a2bb2oi_4
X_0859_ net52 net371 net76 net53 VGND VGND VPWR VPWR _0213_ sky130_fd_sc_hd__a31o_1
X_0928_ _0245_ _0253_ _0255_ VGND VGND VPWR VPWR _0261_ sky130_fd_sc_hd__o21ai_1
XFILLER_45_57 VGND VGND VPWR VPWR sky130_fd_sc_hd__decap_4
XTAP_TAPCELL_ROW_41_338 VGND VPWR sky130_fd_sc_hd__tapvpwrvgnd_1
XFILLER_6_29 VPWR VGND VPWR VGND sky130_ef_sc_hd__decap_12
XFILLER_19_167 VGND VGND VPWR VPWR sky130_fd_sc_hd__fill_1
XFILLER_42_170 VGND VGND VPWR VPWR sky130_fd_sc_hd__fill_2
X_0713_ product_reg\[1\] net48 VGND VGND VPWR VPWR _0090_ sky130_fd_sc_hd__or2_1
XFILLER_33_181 VGND VGND VPWR VPWR sky130_fd_sc_hd__fill_1
X_1127_ net261 _0454_ _0073_ _0078_ VGND VGND VPWR VPWR _0456_ sky130_fd_sc_hd__o2bb2ai_2
X_1058_ _0385_ _0386_ _0075_ net89 VGND VGND VPWR VPWR _0388_ sky130_fd_sc_hd__o2bb2a_2
XFILLER_31_15 VPWR VGND VPWR VGND sky130_ef_sc_hd__decap_12
Xoutput59 net59 VGND VGND VPWR VPWR psum[2] sky130_fd_sc_hd__buf_2
Xoutput26 net26 VGND VGND VPWR VPWR a_out[5] sky130_fd_sc_hd__buf_2
Xoutput48 net363 VGND VGND VPWR VPWR psum[1] sky130_fd_sc_hd__buf_6
XFILLER_0_225 VPWR VGND VPWR VGND sky130_ef_sc_hd__decap_12
XPHY_EDGE_ROW_1_Right_1 VGND VGND VPWR VPWR sky130_fd_sc_hd__decap_3
Xoutput37 net37 VGND VGND VPWR VPWR psum[0] sky130_fd_sc_hd__buf_2
XFILLER_47_273 VGND VGND VPWR VPWR sky130_fd_sc_hd__decap_6
XFILLER_22_129 VGND VGND VPWR VPWR sky130_fd_sc_hd__decap_3
XFILLER_30_195 VGND VGND VPWR VPWR sky130_fd_sc_hd__fill_1
XFILLER_38_251 VGND VGND VPWR VPWR sky130_fd_sc_hd__fill_1
XTAP_TAPCELL_ROW_8_155 VGND VPWR sky130_fd_sc_hd__tapvpwrvgnd_1
XFILLER_29_262 VGND VGND VPWR VPWR sky130_fd_sc_hd__decap_8
X_1392_ clknet_3_7__leaf_clk _0018_ VGND VGND VPWR VPWR net45 sky130_fd_sc_hd__dfxtp_1
XFILLER_35_221 VGND VGND VPWR VPWR sky130_fd_sc_hd__decap_3
XFILLER_2_309 VGND VGND VPWR VPWR sky130_fd_sc_hd__fill_2
XFILLER_37_47 VGND VGND VPWR VPWR sky130_fd_sc_hd__decap_8
Xrebuffer230 net366 VGND VGND VPWR VPWR net365 sky130_fd_sc_hd__dlymetal6s2s_1
Xrebuffer241 _0314_ VGND VGND VPWR VPWR net376 sky130_fd_sc_hd__buf_6
XFILLER_5_169 VPWR VGND VPWR VGND sky130_ef_sc_hd__decap_12
XFILLER_5_125 VPWR VGND VPWR VGND sky130_ef_sc_hd__decap_12
Xrebuffer252 _0308_ VGND VGND VPWR VPWR net387 sky130_fd_sc_hd__buf_2
XTAP_TAPCELL_ROW_19_216 VGND VPWR sky130_fd_sc_hd__tapvpwrvgnd_1
XFILLER_17_243 VGND VGND VPWR VPWR sky130_fd_sc_hd__decap_3
XTAP_TAPCELL_ROW_27_260 VGND VPWR sky130_fd_sc_hd__tapvpwrvgnd_1
X_0961_ _0075_ _0078_ _0291_ _0289_ VGND VGND VPWR VPWR _0293_ sky130_fd_sc_hd__o22ai_4
X_0892_ _0077_ net81 VGND VGND VPWR VPWR _0040_ sky130_fd_sc_hd__nor2_1
XTAP_TAPCELL_ROW_10_171 VGND VPWR sky130_fd_sc_hd__tapvpwrvgnd_1
X_1375_ clknet_3_4__leaf_clk _0001_ VGND VGND VPWR VPWR net37 sky130_fd_sc_hd__dfxtp_4
XTAP_TAPCELL_ROW_33_296 VGND VPWR sky130_fd_sc_hd__tapvpwrvgnd_1
XFILLER_2_139 VGND VGND VPWR VPWR sky130_fd_sc_hd__fill_1
XFILLER_48_57 VPWR VGND VPWR VGND sky130_ef_sc_hd__decap_12
XFILLER_14_235 VPWR VGND VPWR VGND sky130_ef_sc_hd__decap_12
Xfanout72 _0197_ VGND VGND VPWR VPWR net72 sky130_fd_sc_hd__buf_6
Xfanout83 net88 VGND VGND VPWR VPWR net83 sky130_fd_sc_hd__buf_2
Xfanout94 net8 VGND VGND VPWR VPWR net94 sky130_fd_sc_hd__buf_6
XFILLER_1_161 VGND VGND VPWR VPWR sky130_fd_sc_hd__decap_6
XFILLER_49_165 VGND VGND VPWR VPWR sky130_fd_sc_hd__decap_3
Xclkbuf_3_7__f_clk clknet_0_clk VGND VGND VPWR VPWR clknet_3_7__leaf_clk sky130_fd_sc_hd__clkbuf_16
X_1091_ _0418_ _0417_ _0406_ _0407_ VGND VGND VPWR VPWR _0421_ sky130_fd_sc_hd__o211ai_4
X_1160_ _0483_ _0484_ _0480_ VGND VGND VPWR VPWR _0489_ sky130_fd_sc_hd__a21oi_2
XFILLER_9_261 VPWR VGND VPWR VGND sky130_ef_sc_hd__decap_12
X_0944_ _0275_ _0276_ VGND VGND VPWR VPWR _0277_ sky130_fd_sc_hd__nor2_1
X_0875_ _0195_ _0182_ net57 _0193_ _0222_ VGND VGND VPWR VPWR _0225_ sky130_fd_sc_hd__o2111ai_1
XTAP_TAPCELL_ROW_30_277 VGND VPWR sky130_fd_sc_hd__tapvpwrvgnd_1
X_1427_ clknet_3_1__leaf_clk _0053_ VGND VGND VPWR VPWR product_reg\[10\] sky130_fd_sc_hd__dfxtp_1
X_1358_ _0679_ net73 VGND VGND VPWR VPWR _0681_ sky130_fd_sc_hd__nor2_1
XTAP_TAPCELL_ROW_38_322 VGND VPWR sky130_fd_sc_hd__tapvpwrvgnd_1
X_1289_ _0608_ _0609_ _0611_ _0612_ VGND VGND VPWR VPWR _0615_ sky130_fd_sc_hd__and4_1
Xclkload3 clknet_3_3__leaf_clk VGND VGND VPWR VPWR clkload3/Y sky130_fd_sc_hd__clkinvlp_4
XFILLER_19_305 VGND VGND VPWR VPWR sky130_fd_sc_hd__fill_2
XTAP_TAPCELL_ROW_44_358 VGND VPWR sky130_fd_sc_hd__tapvpwrvgnd_1
XFILLER_6_253 VPWR VGND VPWR VGND sky130_ef_sc_hd__decap_12
XFILLER_10_260 VPWR VGND VPWR VGND sky130_ef_sc_hd__decap_12
XFILLER_37_113 VGND VGND VPWR VPWR sky130_fd_sc_hd__fill_1
X_1212_ _0451_ _0454_ VGND VGND VPWR VPWR _0540_ sky130_fd_sc_hd__nand2_1
XFILLER_52_105 VGND VGND VPWR VPWR sky130_fd_sc_hd__decap_6
X_1074_ net142 _0403_ _0402_ VGND VGND VPWR VPWR _0404_ sky130_fd_sc_hd__o21ai_2
X_1143_ _0457_ _0452_ _0470_ _0468_ _0456_ VGND VGND VPWR VPWR _0472_ sky130_fd_sc_hd__o2111a_1
X_0927_ net393 net86 _0085_ _0260_ VGND VGND VPWR VPWR _0046_ sky130_fd_sc_hd__a31o_1
X_0789_ net79 net412 net83 _0156_ VGND VGND VPWR VPWR _0011_ sky130_fd_sc_hd__o211a_1
X_0858_ _0212_ _0211_ net86 VGND VGND VPWR VPWR _0024_ sky130_fd_sc_hd__and3_1
XTAP_TAPCELL_ROW_41_339 VGND VPWR sky130_fd_sc_hd__tapvpwrvgnd_1
XFILLER_3_223 VGND VGND VPWR VPWR sky130_fd_sc_hd__fill_1
XFILLER_19_113 VGND VGND VPWR VPWR sky130_fd_sc_hd__fill_2
XFILLER_34_138 VGND VGND VPWR VPWR sky130_fd_sc_hd__fill_2
XFILLER_34_127 VGND VGND VPWR VPWR sky130_fd_sc_hd__decap_4
X_0712_ product_reg\[1\] net48 VGND VGND VPWR VPWR _0089_ sky130_fd_sc_hd__nor2_1
X_1126_ net104 net120 _0454_ _0453_ VGND VGND VPWR VPWR _0455_ sky130_fd_sc_hd__a22oi_4
X_1057_ _0386_ VGND VGND VPWR VPWR _0387_ sky130_fd_sc_hd__inv_2
XFILLER_31_27 VGND VGND VPWR VPWR sky130_fd_sc_hd__decap_4
Xoutput38 net38 VGND VGND VPWR VPWR psum[10] sky130_fd_sc_hd__buf_2
Xoutput49 net49 VGND VGND VPWR VPWR psum[20] sky130_fd_sc_hd__buf_2
Xoutput27 net27 VGND VGND VPWR VPWR a_out[6] sky130_fd_sc_hd__buf_2
XFILLER_0_237 VPWR VGND VPWR VGND sky130_ef_sc_hd__decap_12
XFILLER_16_149 VGND VGND VPWR VPWR sky130_fd_sc_hd__fill_2
XFILLER_31_119 VPWR VGND VPWR VGND sky130_ef_sc_hd__decap_12
Xclkbuf_0_clk clk VGND VGND VPWR VPWR clknet_0_clk sky130_fd_sc_hd__clkbuf_16
XFILLER_7_73 VPWR VGND VPWR VGND sky130_ef_sc_hd__decap_12
XPHY_EDGE_ROW_15_Left_68 VGND VGND VPWR VPWR sky130_fd_sc_hd__decap_3
XPHY_EDGE_ROW_15_Right_15 VGND VGND VPWR VPWR sky130_fd_sc_hd__decap_3
XFILLER_38_296 VGND VGND VPWR VPWR sky130_fd_sc_hd__fill_1
XFILLER_38_285 VGND VGND VPWR VPWR sky130_fd_sc_hd__decap_4
XFILLER_38_263 VPWR VGND VPWR VGND sky130_ef_sc_hd__decap_12
XFILLER_38_230 VGND VGND VPWR VPWR sky130_fd_sc_hd__fill_1
XPHY_EDGE_ROW_24_Right_24 VGND VGND VPWR VPWR sky130_fd_sc_hd__decap_3
XFILLER_26_27 VGND VGND VPWR VPWR sky130_fd_sc_hd__fill_1
X_1109_ _0438_ VGND VGND VPWR VPWR _0439_ sky130_fd_sc_hd__inv_2
XPHY_EDGE_ROW_33_Right_33 VGND VGND VPWR VPWR sky130_fd_sc_hd__decap_3
XTAP_TAPCELL_ROW_8_156 VGND VPWR sky130_fd_sc_hd__tapvpwrvgnd_1
XFILLER_29_241 VPWR VGND VPWR VGND sky130_ef_sc_hd__decap_12
XFILLER_44_244 VGND VGND VPWR VPWR sky130_fd_sc_hd__decap_8
XPHY_EDGE_ROW_42_Right_42 VGND VGND VPWR VPWR sky130_fd_sc_hd__decap_3
XPHY_EDGE_ROW_51_Right_51 VGND VGND VPWR VPWR sky130_fd_sc_hd__decap_3
XFILLER_12_130 VGND VGND VPWR VPWR sky130_fd_sc_hd__fill_1
X_1391_ clknet_3_7__leaf_clk _0017_ VGND VGND VPWR VPWR net44 sky130_fd_sc_hd__dfxtp_2
XFILLER_12_29 VGND VGND VPWR VPWR sky130_fd_sc_hd__fill_1
XFILLER_41_225 VGND VGND VPWR VPWR sky130_fd_sc_hd__decap_6
XFILLER_41_214 VGND VGND VPWR VPWR sky130_fd_sc_hd__decap_8
XFILLER_26_211 VGND VGND VPWR VPWR sky130_fd_sc_hd__fill_1
Xrebuffer231 net367 VGND VGND VPWR VPWR net366 sky130_fd_sc_hd__dlygate4sd1_1
XFILLER_5_137 VPWR VGND VPWR VGND sky130_ef_sc_hd__decap_12
Xrebuffer242 _0307_ VGND VGND VPWR VPWR net377 sky130_fd_sc_hd__buf_6
XFILLER_17_222 VGND VGND VPWR VPWR sky130_fd_sc_hd__fill_2
XTAP_TAPCELL_ROW_19_217 VGND VPWR sky130_fd_sc_hd__tapvpwrvgnd_1
XFILLER_43_91 VPWR VGND VPWR VGND sky130_ef_sc_hd__decap_12
X_0960_ net108 net127 net112 net193 VGND VGND VPWR VPWR _0292_ sky130_fd_sc_hd__a22o_1
XTAP_TAPCELL_ROW_27_261 VGND VPWR sky130_fd_sc_hd__tapvpwrvgnd_1
XFILLER_40_291 VGND VGND VPWR VPWR sky130_fd_sc_hd__decap_4
X_0891_ _0076_ net81 VGND VGND VPWR VPWR _0039_ sky130_fd_sc_hd__nor2_1
XFILLER_4_85 VPWR VGND VPWR VGND sky130_ef_sc_hd__decap_12
XFILLER_4_41 VPWR VGND VPWR VGND sky130_ef_sc_hd__decap_12
X_1374_ clknet_3_5__leaf_clk _0000_ VGND VGND VPWR VPWR v_pipe sky130_fd_sc_hd__dfxtp_1
XFILLER_23_247 VGND VGND VPWR VPWR sky130_fd_sc_hd__decap_4
XTAP_TAPCELL_ROW_33_297 VGND VPWR sky130_fd_sc_hd__tapvpwrvgnd_1
XFILLER_23_258 VGND VGND VPWR VPWR sky130_fd_sc_hd__decap_4
XPHY_EDGE_ROW_18_Left_71 VGND VGND VPWR VPWR sky130_fd_sc_hd__decap_3
XFILLER_48_69 VPWR VGND VPWR VGND sky130_ef_sc_hd__decap_12
XFILLER_14_247 VGND VGND VPWR VPWR sky130_fd_sc_hd__decap_4
Xfanout84 net85 VGND VGND VPWR VPWR net84 sky130_fd_sc_hd__clkbuf_2
XFILLER_13_83 VPWR VGND VPWR VGND sky130_ef_sc_hd__decap_12
Xfanout95 net97 VGND VGND VPWR VPWR net95 sky130_fd_sc_hd__buf_12
XFILLER_49_100 VGND VGND VPWR VPWR sky130_fd_sc_hd__decap_6
XFILLER_52_309 VGND VGND VPWR VPWR sky130_fd_sc_hd__fill_2
XFILLER_38_80 VGND VGND VPWR VPWR sky130_fd_sc_hd__decap_4
X_1090_ _0407_ _0406_ _0413_ _0415_ VGND VGND VPWR VPWR _0420_ sky130_fd_sc_hd__o2bb2ai_4
X_0874_ _0195_ _0182_ _0193_ _0223_ VGND VGND VPWR VPWR _0224_ sky130_fd_sc_hd__o211a_1
XFILLER_9_273 VGND VGND VPWR VPWR sky130_fd_sc_hd__decap_6
X_0943_ net111 net127 net123 net135 VGND VGND VPWR VPWR _0276_ sky130_fd_sc_hd__a22oi_1
XTAP_TAPCELL_ROW_30_278 VGND VPWR sky130_fd_sc_hd__tapvpwrvgnd_1
X_1426_ clknet_3_1__leaf_clk _0052_ VGND VGND VPWR VPWR product_reg\[9\] sky130_fd_sc_hd__dfxtp_1
XTAP_TAPCELL_ROW_38_323 VGND VPWR sky130_fd_sc_hd__tapvpwrvgnd_1
X_1357_ net165 net116 _0080_ net89 _0677_ VGND VGND VPWR VPWR _0680_ sky130_fd_sc_hd__a2111oi_1
X_1288_ _0078_ _0080_ _0527_ _0608_ _0612_ VGND VGND VPWR VPWR _0614_ sky130_fd_sc_hd__o311a_1
XFILLER_34_27 VGND VGND VPWR VPWR sky130_fd_sc_hd__fill_1
XFILLER_50_15 VPWR VGND VPWR VGND sky130_ef_sc_hd__decap_12
Xclkload4 clknet_3_4__leaf_clk VGND VGND VPWR VPWR clkload4/Y sky130_fd_sc_hd__bufinv_16
XPHY_EDGE_ROW_3_Left_56 VGND VGND VPWR VPWR sky130_fd_sc_hd__decap_3
XFILLER_34_309 VGND VGND VPWR VPWR sky130_fd_sc_hd__fill_2
XFILLER_6_265 VPWR VGND VPWR VGND sky130_ef_sc_hd__decap_12
XFILLER_6_221 VPWR VGND VPWR VGND sky130_ef_sc_hd__decap_12
XFILLER_10_272 VPWR VGND VPWR VGND sky130_ef_sc_hd__decap_12
X_1142_ _0457_ _0452_ _0456_ _0470_ VGND VGND VPWR VPWR _0471_ sky130_fd_sc_hd__o211ai_4
X_1211_ _0464_ _0466_ _0534_ net160 _0536_ VGND VGND VPWR VPWR _0539_ sky130_fd_sc_hd__o2111ai_4
XTAP_TAPCELL_ROW_35_304 VGND VPWR sky130_fd_sc_hd__tapvpwrvgnd_1
X_1073_ net92 net130 net177 net93 _0395_ VGND VGND VPWR VPWR _0403_ sky130_fd_sc_hd__a41o_4
X_0857_ net77 net52 _0196_ net76 VGND VGND VPWR VPWR _0212_ sky130_fd_sc_hd__nand4_1
X_0926_ _0259_ net80 net85 _0258_ VGND VGND VPWR VPWR _0260_ sky130_fd_sc_hd__and4b_1
X_0788_ _0154_ _0155_ _0070_ VGND VGND VPWR VPWR _0156_ sky130_fd_sc_hd__a21o_1
XPHY_EDGE_ROW_45_Left_98 VGND VGND VPWR VPWR sky130_fd_sc_hd__decap_3
X_1409_ clknet_3_5__leaf_clk _0035_ VGND VGND VPWR VPWR net21 sky130_fd_sc_hd__dfxtp_1
XFILLER_45_15 VPWR VGND VPWR VGND sky130_ef_sc_hd__decap_12
XFILLER_16_309 VGND VGND VPWR VPWR sky130_fd_sc_hd__fill_2
XFILLER_3_279 VGND VGND VPWR VPWR sky130_fd_sc_hd__fill_1
XFILLER_42_150 VPWR VGND VPWR VGND sky130_ef_sc_hd__decap_12
XFILLER_34_106 VGND VGND VPWR VPWR sky130_fd_sc_hd__decap_4
X_0711_ net404 _0088_ VGND VGND VPWR VPWR _0001_ sky130_fd_sc_hd__nor2_1
X_1125_ net12 net102 net122 net99 VGND VGND VPWR VPWR _0454_ sky130_fd_sc_hd__nand4_4
XFILLER_15_29 VGND VGND VPWR VPWR sky130_fd_sc_hd__fill_1
X_1056_ _0340_ _0341_ net343 _0382_ VGND VGND VPWR VPWR _0386_ sky130_fd_sc_hd__o211ai_4
Xoutput39 net39 VGND VGND VPWR VPWR psum[11] sky130_fd_sc_hd__buf_2
Xoutput28 net28 VGND VGND VPWR VPWR a_out[7] sky130_fd_sc_hd__buf_2
X_0909_ _0242_ _0243_ net84 net80 VGND VGND VPWR VPWR _0244_ sky130_fd_sc_hd__and4b_1
XFILLER_48_209 VGND VGND VPWR VPWR sky130_fd_sc_hd__fill_1
XFILLER_0_249 VGND VGND VPWR VPWR sky130_fd_sc_hd__decap_3
XFILLER_31_109 VGND VGND VPWR VPWR sky130_fd_sc_hd__decap_3
XFILLER_21_61 VGND VGND VPWR VPWR sky130_fd_sc_hd__fill_1
XFILLER_39_209 VGND VGND VPWR VPWR sky130_fd_sc_hd__decap_4
XFILLER_7_85 VPWR VGND VPWR VGND sky130_ef_sc_hd__decap_12
XFILLER_7_63 VGND VGND VPWR VPWR sky130_fd_sc_hd__fill_1
XFILLER_30_197 VPWR VGND VPWR VGND sky130_ef_sc_hd__decap_12
XFILLER_38_275 VGND VGND VPWR VPWR sky130_fd_sc_hd__fill_1
X_1039_ _0359_ _0361_ _0369_ VGND VGND VPWR VPWR _0370_ sky130_fd_sc_hd__a21o_1
X_1108_ _0358_ _0380_ _0431_ _0432_ VGND VGND VPWR VPWR _0438_ sky130_fd_sc_hd__o211ai_4
XTAP_TAPCELL_ROW_8_157 VGND VPWR sky130_fd_sc_hd__tapvpwrvgnd_1
XFILLER_44_212 VGND VGND VPWR VPWR sky130_fd_sc_hd__decap_8
XFILLER_29_253 VGND VGND VPWR VPWR sky130_fd_sc_hd__fill_1
XPHY_EDGE_ROW_32_Left_85 VGND VGND VPWR VPWR sky130_fd_sc_hd__decap_3
XFILLER_16_83 VGND VGND VPWR VPWR sky130_fd_sc_hd__fill_1
XFILLER_12_197 VGND VGND VPWR VPWR sky130_fd_sc_hd__fill_2
X_1390_ clknet_3_3__leaf_clk _0016_ VGND VGND VPWR VPWR net43 sky130_fd_sc_hd__dfxtp_1
XFILLER_35_245 VGND VGND VPWR VPWR sky130_fd_sc_hd__decap_8
XFILLER_35_201 VPWR VGND VPWR VGND sky130_ef_sc_hd__decap_12
Xrebuffer232 net368 VGND VGND VPWR VPWR net367 sky130_fd_sc_hd__dlygate4sd1_1
XFILLER_5_149 VPWR VGND VPWR VGND sky130_ef_sc_hd__decap_12
XFILLER_5_105 VGND VGND VPWR VPWR sky130_fd_sc_hd__decap_6
Xrebuffer243 _0287_ VGND VGND VPWR VPWR net378 sky130_fd_sc_hd__clkbuf_2
XFILLER_32_204 VGND VGND VPWR VPWR sky130_fd_sc_hd__decap_8
XTAP_TAPCELL_ROW_19_218 VGND VPWR sky130_fd_sc_hd__tapvpwrvgnd_1
XFILLER_43_81 VGND VGND VPWR VPWR sky130_fd_sc_hd__fill_2
X_0890_ _0073_ net81 VGND VGND VPWR VPWR _0038_ sky130_fd_sc_hd__nor2_1
XTAP_TAPCELL_ROW_27_262 VGND VPWR sky130_fd_sc_hd__tapvpwrvgnd_1
X_1373_ net89 net81 VGND VGND VPWR VPWR _0066_ sky130_fd_sc_hd__nor2_1
XFILLER_4_97 VPWR VGND VPWR VGND sky130_ef_sc_hd__decap_12
XFILLER_4_53 VPWR VGND VPWR VGND sky130_ef_sc_hd__decap_12
XFILLER_48_15 VPWR VGND VPWR VGND sky130_ef_sc_hd__decap_12
Xfanout85 net88 VGND VGND VPWR VPWR net85 sky130_fd_sc_hd__buf_1
Xfanout96 net97 VGND VGND VPWR VPWR net96 sky130_fd_sc_hd__clkbuf_4
XTAP_TAPCELL_ROW_24_243 VGND VPWR sky130_fd_sc_hd__tapvpwrvgnd_1
XFILLER_49_189 VPWR VGND VPWR VGND sky130_ef_sc_hd__decap_12
X_0873_ net76 _0216_ _0221_ VGND VGND VPWR VPWR _0223_ sky130_fd_sc_hd__and3_1
XFILLER_13_281 VPWR VGND VPWR VGND sky130_ef_sc_hd__decap_12
X_0942_ net123 net135 net126 net111 VGND VGND VPWR VPWR _0275_ sky130_fd_sc_hd__and4_1
XTAP_TAPCELL_ROW_30_279 VGND VPWR sky130_fd_sc_hd__tapvpwrvgnd_1
X_1425_ clknet_3_1__leaf_clk _0051_ VGND VGND VPWR VPWR product_reg\[8\] sky130_fd_sc_hd__dfxtp_1
X_1356_ _0080_ net89 _0632_ _0677_ VGND VGND VPWR VPWR _0679_ sky130_fd_sc_hd__o31a_1
XTAP_TAPCELL_ROW_38_324 VGND VPWR sky130_fd_sc_hd__tapvpwrvgnd_1
XFILLER_28_307 VGND VGND VPWR VPWR sky130_fd_sc_hd__fill_1
X_1287_ _0608_ _0609_ _0611_ _0612_ VGND VGND VPWR VPWR _0613_ sky130_fd_sc_hd__a22oi_4
Xclkload5 clknet_3_6__leaf_clk VGND VGND VPWR VPWR clkload5/Y sky130_fd_sc_hd__bufinv_16
XFILLER_50_27 VGND VGND VPWR VPWR sky130_fd_sc_hd__fill_1
XFILLER_6_233 VPWR VGND VPWR VGND sky130_ef_sc_hd__decap_12
XFILLER_10_251 VGND VGND VPWR VPWR sky130_fd_sc_hd__fill_1
XFILLER_10_284 VPWR VGND VPWR VGND sky130_ef_sc_hd__decap_12
XFILLER_24_50 VGND VGND VPWR VPWR sky130_fd_sc_hd__fill_2
XFILLER_24_83 VGND VGND VPWR VPWR sky130_fd_sc_hd__fill_1
XFILLER_40_82 VGND VGND VPWR VPWR sky130_fd_sc_hd__fill_2
XFILLER_6_277 VPWR VGND VPWR VGND sky130_ef_sc_hd__decap_12
X_1072_ _0074_ _0077_ net298 _0398_ VGND VGND VPWR VPWR _0402_ sky130_fd_sc_hd__o22ai_4
X_1141_ _0329_ _0461_ _0460_ _0397_ _0465_ VGND VGND VPWR VPWR _0470_ sky130_fd_sc_hd__o2111ai_4
X_1210_ _0464_ _0466_ _0534_ _0535_ _0536_ VGND VGND VPWR VPWR _0538_ sky130_fd_sc_hd__o2111a_1
XTAP_TAPCELL_ROW_35_305 VGND VPWR sky130_fd_sc_hd__tapvpwrvgnd_1
X_0856_ v_pipe _0196_ net76 net52 VGND VGND VPWR VPWR _0211_ sky130_fd_sc_hd__a31o_1
X_0787_ product_reg\[9\] net68 _0151_ _0152_ _0153_ VGND VGND VPWR VPWR _0155_ sky130_fd_sc_hd__o2111ai_4
XFILLER_20_19 VGND VGND VPWR VPWR sky130_fd_sc_hd__fill_2
X_0925_ _0256_ _0257_ net75 VGND VGND VPWR VPWR _0259_ sky130_fd_sc_hd__a21oi_1
X_1408_ clknet_3_2__leaf_clk _0034_ VGND VGND VPWR VPWR net70 sky130_fd_sc_hd__dfxtp_1
XFILLER_45_27 VPWR VGND VPWR VGND sky130_ef_sc_hd__decap_12
XFILLER_43_118 VGND VGND VPWR VPWR sky130_fd_sc_hd__fill_2
X_1339_ _0610_ _0661_ _0662_ VGND VGND VPWR VPWR _0663_ sky130_fd_sc_hd__o21ai_1
XFILLER_28_148 VGND VGND VPWR VPWR sky130_fd_sc_hd__fill_2
XFILLER_3_225 VPWR VGND VPWR VGND sky130_ef_sc_hd__decap_12
XFILLER_10_85 VGND VGND VPWR VPWR sky130_fd_sc_hd__decap_4
XFILLER_19_50 VGND VGND VPWR VPWR sky130_fd_sc_hd__decap_6
XFILLER_42_195 VGND VGND VPWR VPWR sky130_fd_sc_hd__fill_1
XFILLER_42_162 VGND VGND VPWR VPWR sky130_fd_sc_hd__decap_8
X_0710_ product_reg\[0\] net78 net37 net81 VGND VGND VPWR VPWR _0088_ sky130_fd_sc_hd__a31o_1
XFILLER_25_3 VGND VGND VPWR VPWR sky130_fd_sc_hd__fill_1
X_1124_ net102 net121 net99 net125 VGND VGND VPWR VPWR _0453_ sky130_fd_sc_hd__a22o_4
X_1055_ _0383_ net117 net110 _0342_ VGND VGND VPWR VPWR _0385_ sky130_fd_sc_hd__nand4_2
XFILLER_33_173 VGND VGND VPWR VPWR sky130_fd_sc_hd__fill_1
X_0839_ _0196_ net45 net44 net77 VGND VGND VPWR VPWR _0200_ sky130_fd_sc_hd__nand4_1
X_0908_ _0240_ _0241_ _0234_ VGND VGND VPWR VPWR _0243_ sky130_fd_sc_hd__o21ai_1
Xoutput29 net29 VGND VGND VPWR VPWR b_out[0] sky130_fd_sc_hd__buf_2
XFILLER_47_287 VGND VGND VPWR VPWR sky130_fd_sc_hd__fill_1
XFILLER_15_151 VGND VGND VPWR VPWR sky130_fd_sc_hd__fill_2
XFILLER_30_154 VGND VGND VPWR VPWR sky130_fd_sc_hd__fill_2
XFILLER_7_97 VGND VGND VPWR VPWR sky130_fd_sc_hd__decap_4
XFILLER_38_221 VGND VGND VPWR VPWR sky130_fd_sc_hd__fill_2
XPHY_EDGE_ROW_5_Right_5 VGND VGND VPWR VPWR sky130_fd_sc_hd__decap_3
X_1038_ _0366_ _0367_ VGND VGND VPWR VPWR _0369_ sky130_fd_sc_hd__nand2_2
X_1107_ _0381_ _0434_ _0433_ VGND VGND VPWR VPWR _0437_ sky130_fd_sc_hd__nand3_4
XTAP_TAPCELL_ROW_8_158 VGND VPWR sky130_fd_sc_hd__tapvpwrvgnd_1
XFILLER_12_110 VGND VGND VPWR VPWR sky130_fd_sc_hd__decap_3
XFILLER_16_51 VGND VGND VPWR VPWR sky130_fd_sc_hd__fill_1
XFILLER_32_83 VGND VGND VPWR VPWR sky130_fd_sc_hd__fill_1
XFILLER_32_50 VGND VGND VPWR VPWR sky130_fd_sc_hd__decap_4
XFILLER_50_238 VGND VGND VPWR VPWR sky130_fd_sc_hd__decap_3
XFILLER_50_227 VGND VGND VPWR VPWR sky130_fd_sc_hd__decap_6
XFILLER_35_213 VGND VGND VPWR VPWR sky130_fd_sc_hd__decap_8
XTAP_TAPCELL_ROW_5_139 VGND VPWR sky130_fd_sc_hd__tapvpwrvgnd_1
Xrebuffer244 _0295_ VGND VGND VPWR VPWR net379 sky130_fd_sc_hd__dlymetal6s4s_1
Xrebuffer233 net369 VGND VGND VPWR VPWR net368 sky130_fd_sc_hd__dlygate4sd1_1
XFILLER_32_227 VGND VGND VPWR VPWR sky130_fd_sc_hd__fill_1
XFILLER_17_235 VGND VGND VPWR VPWR sky130_fd_sc_hd__decap_8
XFILLER_17_279 VGND VGND VPWR VPWR sky130_fd_sc_hd__fill_1
XTAP_TAPCELL_ROW_19_219 VGND VPWR sky130_fd_sc_hd__tapvpwrvgnd_1
XTAP_TAPCELL_ROW_27_263 VGND VPWR sky130_fd_sc_hd__tapvpwrvgnd_1
XFILLER_4_65 VPWR VGND VPWR VGND sky130_ef_sc_hd__decap_12
X_1372_ _0079_ net81 VGND VGND VPWR VPWR _0065_ sky130_fd_sc_hd__nor2_1
XFILLER_2_109 VPWR VGND VPWR VGND sky130_ef_sc_hd__decap_12
XFILLER_48_49 VGND VGND VPWR VPWR sky130_fd_sc_hd__decap_3
XFILLER_48_27 VGND VGND VPWR VPWR sky130_fd_sc_hd__fill_1
XTAP_TAPCELL_ROW_1_120 VGND VPWR sky130_fd_sc_hd__tapvpwrvgnd_1
Xfanout86 net87 VGND VGND VPWR VPWR net86 sky130_fd_sc_hd__buf_2
Xfanout97 net98 VGND VGND VPWR VPWR net97 sky130_fd_sc_hd__buf_12
XTAP_TAPCELL_ROW_24_244 VGND VPWR sky130_fd_sc_hd__tapvpwrvgnd_1
XFILLER_49_157 VGND VGND VPWR VPWR sky130_fd_sc_hd__decap_8
X_0941_ net111 net123 VGND VGND VPWR VPWR _0274_ sky130_fd_sc_hd__nand2_1
X_0872_ net76 _0216_ _0221_ VGND VGND VPWR VPWR _0222_ sky130_fd_sc_hd__and3_1
XFILLER_13_293 VPWR VGND VPWR VGND sky130_ef_sc_hd__decap_12
X_1355_ _0080_ net89 _0632_ _0677_ VGND VGND VPWR VPWR _0678_ sky130_fd_sc_hd__or4b_1
X_1424_ clknet_3_1__leaf_clk _0050_ VGND VGND VPWR VPWR product_reg\[7\] sky130_fd_sc_hd__dfxtp_1
XTAP_TAPCELL_ROW_38_325 VGND VPWR sky130_fd_sc_hd__tapvpwrvgnd_1
X_1286_ net162 net118 net94 net121 VGND VGND VPWR VPWR _0612_ sky130_fd_sc_hd__a22o_1
XFILLER_34_29 VPWR VGND VPWR VGND sky130_ef_sc_hd__decap_12
XFILLER_40_50 VGND VGND VPWR VPWR sky130_fd_sc_hd__decap_8
XFILLER_6_245 VGND VGND VPWR VPWR sky130_fd_sc_hd__decap_6
XFILLER_10_296 VGND VGND VPWR VPWR sky130_fd_sc_hd__decap_8
XFILLER_6_289 VPWR VGND VPWR VGND sky130_ef_sc_hd__decap_12
XFILLER_37_127 VGND VGND VPWR VPWR sky130_fd_sc_hd__fill_2
XTAP_TAPCELL_ROW_35_306 VGND VPWR sky130_fd_sc_hd__tapvpwrvgnd_1
XFILLER_1_55 VGND VGND VPWR VPWR sky130_fd_sc_hd__fill_1
X_1071_ net149 _0398_ _0395_ VGND VGND VPWR VPWR _0401_ sky130_fd_sc_hd__o21bai_4
X_1140_ _0329_ _0461_ _0465_ _0397_ _0460_ VGND VGND VPWR VPWR _0469_ sky130_fd_sc_hd__o2111a_1
XFILLER_45_182 VGND VGND VPWR VPWR sky130_fd_sc_hd__fill_1
XTAP_TAPCELL_ROW_43_350 VGND VPWR sky130_fd_sc_hd__tapvpwrvgnd_1
X_0924_ _0256_ _0257_ net75 VGND VGND VPWR VPWR _0258_ sky130_fd_sc_hd__nand3_1
X_0786_ _0151_ _0152_ _0153_ _0146_ VGND VGND VPWR VPWR _0154_ sky130_fd_sc_hd__a22o_1
X_0855_ net370 _0210_ _0209_ net81 VGND VGND VPWR VPWR _0023_ sky130_fd_sc_hd__a211oi_2
X_1407_ clknet_3_2__leaf_clk _0033_ VGND VGND VPWR VPWR net69 sky130_fd_sc_hd__dfxtp_1
X_1338_ _0639_ _0660_ VGND VGND VPWR VPWR _0662_ sky130_fd_sc_hd__nand2_1
XFILLER_36_193 VGND VGND VPWR VPWR sky130_fd_sc_hd__decap_3
X_1269_ _0595_ _0594_ _0592_ VGND VGND VPWR VPWR _0596_ sky130_fd_sc_hd__nand3b_1
XFILLER_3_237 VPWR VGND VPWR VGND sky130_ef_sc_hd__decap_12
XFILLER_42_141 VGND VGND VPWR VPWR sky130_fd_sc_hd__fill_2
XTAP_TAPCELL_ROW_40_331 VGND VPWR sky130_fd_sc_hd__tapvpwrvgnd_1
XFILLER_35_50 VGND VGND VPWR VPWR sky130_fd_sc_hd__decap_6
X_1054_ _0383_ net110 _0342_ net117 VGND VGND VPWR VPWR _0384_ sky130_fd_sc_hd__and4_2
X_1123_ net195 net122 net101 net125 VGND VGND VPWR VPWR _0452_ sky130_fd_sc_hd__a22oi_4
XFILLER_33_185 VPWR VGND VPWR VGND sky130_ef_sc_hd__decap_12
X_0907_ _0234_ _0240_ _0241_ VGND VGND VPWR VPWR _0242_ sky130_fd_sc_hd__nor3_1
X_0838_ net77 net44 _0196_ net45 VGND VGND VPWR VPWR _0199_ sky130_fd_sc_hd__a31o_1
X_0769_ product_reg\[8\] net67 VGND VGND VPWR VPWR _0139_ sky130_fd_sc_hd__or2_1
XFILLER_8_307 VGND VGND VPWR VPWR sky130_fd_sc_hd__fill_1
XFILLER_24_185 VGND VGND VPWR VPWR sky130_fd_sc_hd__decap_6
XFILLER_30_111 VGND VGND VPWR VPWR sky130_fd_sc_hd__fill_1
XFILLER_30_177 VPWR VGND VPWR VGND sky130_ef_sc_hd__decap_12
XFILLER_26_19 VGND VGND VPWR VPWR sky130_fd_sc_hd__fill_2
X_1106_ _0434_ _0381_ net347 VGND VGND VPWR VPWR _0436_ sky130_fd_sc_hd__and3_1
XFILLER_42_29 VPWR VGND VPWR VGND sky130_ef_sc_hd__decap_12
X_1037_ _0362_ _0365_ VGND VGND VPWR VPWR _0368_ sky130_fd_sc_hd__xor2_1
XFILLER_21_166 VGND VGND VPWR VPWR sky130_fd_sc_hd__fill_2
XTAP_TAPCELL_ROW_8_159 VGND VPWR sky130_fd_sc_hd__tapvpwrvgnd_1
XFILLER_8_137 VGND VGND VPWR VPWR sky130_fd_sc_hd__decap_3
XPHY_EDGE_ROW_11_Right_11 VGND VGND VPWR VPWR sky130_fd_sc_hd__decap_3
XPHY_EDGE_ROW_20_Right_20 VGND VGND VPWR VPWR sky130_fd_sc_hd__decap_3
XFILLER_35_225 VGND VGND VPWR VPWR sky130_fd_sc_hd__fill_1
XTAP_TAPCELL_ROW_13_183 VGND VPWR sky130_fd_sc_hd__tapvpwrvgnd_1
XFILLER_37_18 VGND VGND VPWR VPWR sky130_fd_sc_hd__fill_1
Xrebuffer223 _0103_ VGND VGND VPWR VPWR net358 sky130_fd_sc_hd__dlygate4sd1_1
Xrebuffer212 _0433_ VGND VGND VPWR VPWR net347 sky130_fd_sc_hd__dlymetal6s2s_1
Xrebuffer234 net48 VGND VGND VPWR VPWR net369 sky130_fd_sc_hd__dlymetal6s2s_1
Xrebuffer245 _0293_ VGND VGND VPWR VPWR net380 sky130_fd_sc_hd__dlygate4sd1_1
XTAP_TAPCELL_ROW_27_264 VGND VPWR sky130_fd_sc_hd__tapvpwrvgnd_1
X_1440_ clknet_3_0__leaf_clk _0066_ VGND VGND VPWR VPWR net36 sky130_fd_sc_hd__dfxtp_1
XFILLER_4_195 VGND VGND VPWR VPWR sky130_fd_sc_hd__fill_1
XFILLER_4_77 VGND VGND VPWR VPWR sky130_fd_sc_hd__decap_6
X_1371_ _0078_ net82 VGND VGND VPWR VPWR _0064_ sky130_fd_sc_hd__nor2_1
Xclkbuf_3_2__f_clk clknet_0_clk VGND VGND VPWR VPWR clknet_3_2__leaf_clk sky130_fd_sc_hd__clkbuf_16
XFILLER_31_272 VGND VGND VPWR VPWR sky130_fd_sc_hd__fill_1
XFILLER_23_228 VGND VGND VPWR VPWR sky130_fd_sc_hd__fill_1
XFILLER_46_309 VGND VGND VPWR VPWR sky130_fd_sc_hd__fill_2
XTAP_TAPCELL_ROW_1_121 VGND VPWR sky130_fd_sc_hd__tapvpwrvgnd_1
Xfanout76 _0210_ VGND VGND VPWR VPWR net76 sky130_fd_sc_hd__clkbuf_2
Xfanout87 net88 VGND VGND VPWR VPWR net87 sky130_fd_sc_hd__buf_2
Xfanout98 net7 VGND VGND VPWR VPWR net98 sky130_fd_sc_hd__buf_6
XFILLER_13_53 VGND VGND VPWR VPWR sky130_fd_sc_hd__decap_3
XTAP_TAPCELL_ROW_24_245 VGND VPWR sky130_fd_sc_hd__tapvpwrvgnd_1
XFILLER_49_169 VGND VGND VPWR VPWR sky130_fd_sc_hd__decap_4
XFILLER_49_147 VGND VGND VPWR VPWR sky130_fd_sc_hd__decap_4
X_0940_ _0271_ _0265_ _0262_ _0270_ VGND VGND VPWR VPWR _0273_ sky130_fd_sc_hd__o211ai_4
X_0871_ net77 net56 net55 VGND VGND VPWR VPWR _0221_ sky130_fd_sc_hd__and3_1
XPHY_EDGE_ROW_50_Left_103 VGND VGND VPWR VPWR sky130_fd_sc_hd__decap_3
XFILLER_48_3 VPWR VGND VPWR VGND sky130_ef_sc_hd__decap_12
X_1354_ _0610_ _0661_ _0662_ _0658_ VGND VGND VPWR VPWR _0677_ sky130_fd_sc_hd__a2bb2o_1
X_1423_ clknet_3_4__leaf_clk _0049_ VGND VGND VPWR VPWR product_reg\[6\] sky130_fd_sc_hd__dfxtp_1
X_1285_ net121 net161 net118 net94 VGND VGND VPWR VPWR _0611_ sky130_fd_sc_hd__nand4_4
XFILLER_28_309 VGND VGND VPWR VPWR sky130_fd_sc_hd__fill_2
XFILLER_50_29 VPWR VGND VPWR VGND sky130_ef_sc_hd__decap_12
XFILLER_46_106 VPWR VGND VPWR VGND sky130_ef_sc_hd__decap_12
XFILLER_37_106 VGND VGND VPWR VPWR sky130_fd_sc_hd__decap_6
XTAP_TAPCELL_ROW_35_307 VGND VPWR sky130_fd_sc_hd__tapvpwrvgnd_1
X_1070_ _0074_ _0077_ _0397_ _0399_ VGND VGND VPWR VPWR _0400_ sky130_fd_sc_hd__o211ai_4
X_0854_ net51 net50 net49 _0204_ VGND VGND VPWR VPWR _0210_ sky130_fd_sc_hd__and4_1
XTAP_TAPCELL_ROW_43_351 VGND VPWR sky130_fd_sc_hd__tapvpwrvgnd_1
X_0923_ net135 net126 _0254_ _0255_ VGND VGND VPWR VPWR _0257_ sky130_fd_sc_hd__a22o_1
XPHY_EDGE_ROW_49_Right_49 VGND VGND VPWR VPWR sky130_fd_sc_hd__decap_3
X_0785_ _0138_ _0145_ _0144_ VGND VGND VPWR VPWR _0153_ sky130_fd_sc_hd__nand3_4
X_1406_ clknet_3_6__leaf_clk _0032_ VGND VGND VPWR VPWR net61 sky130_fd_sc_hd__dfxtp_1
X_1337_ _0636_ _0637_ _0660_ VGND VGND VPWR VPWR _0661_ sky130_fd_sc_hd__a21o_1
X_1268_ net107 net115 _0543_ _0541_ VGND VGND VPWR VPWR _0595_ sky130_fd_sc_hd__a31oi_2
XFILLER_28_139 VGND VGND VPWR VPWR sky130_fd_sc_hd__fill_1
X_1199_ net121 net162 VGND VGND VPWR VPWR _0527_ sky130_fd_sc_hd__nand2_1
XFILLER_3_205 VPWR VGND VPWR VGND sky130_ef_sc_hd__decap_12
XFILLER_3_249 VPWR VGND VPWR VGND sky130_ef_sc_hd__decap_12
XFILLER_42_120 VGND VGND VPWR VPWR sky130_fd_sc_hd__decap_3
XFILLER_35_40 VGND VGND VPWR VPWR sky130_fd_sc_hd__fill_2
XFILLER_42_197 VPWR VGND VPWR VGND sky130_ef_sc_hd__decap_12
XFILLER_42_175 VPWR VGND VPWR VGND sky130_ef_sc_hd__decap_12
XTAP_TAPCELL_ROW_40_332 VGND VPWR sky130_fd_sc_hd__tapvpwrvgnd_1
XFILLER_32_6 VGND VGND VPWR VPWR sky130_fd_sc_hd__fill_1
X_1122_ net104 net118 VGND VGND VPWR VPWR _0451_ sky130_fd_sc_hd__nand2_1
XFILLER_33_197 VGND VGND VPWR VPWR sky130_fd_sc_hd__decap_3
X_1053_ _0340_ _0343_ VGND VGND VPWR VPWR _0383_ sky130_fd_sc_hd__nand2_1
X_0837_ net396 net370 _0198_ VGND VGND VPWR VPWR _0017_ sky130_fd_sc_hd__a21oi_1
X_0906_ _0237_ _0239_ net129 net135 VGND VGND VPWR VPWR _0241_ sky130_fd_sc_hd__and4b_1
X_0768_ product_reg\[8\] net67 VGND VGND VPWR VPWR _0138_ sky130_fd_sc_hd__nand2_1
X_0699_ net116 VGND VGND VPWR VPWR _0079_ sky130_fd_sc_hd__inv_6
XFILLER_47_212 VPWR VGND VPWR VGND sky130_ef_sc_hd__decap_12
XFILLER_46_83 VGND VGND VPWR VPWR sky130_fd_sc_hd__fill_1
Xmax_cap73 _0680_ VGND VGND VPWR VPWR net73 sky130_fd_sc_hd__clkbuf_1
XFILLER_30_134 VGND VGND VPWR VPWR sky130_fd_sc_hd__decap_6
XFILLER_30_189 VGND VGND VPWR VPWR sky130_fd_sc_hd__decap_6
XFILLER_30_3 VGND VGND VPWR VPWR sky130_fd_sc_hd__fill_2
X_1105_ _0431_ _0432_ VGND VGND VPWR VPWR _0435_ sky130_fd_sc_hd__nand2_1
X_1036_ _0291_ _0363_ net134 net117 VGND VGND VPWR VPWR _0367_ sky130_fd_sc_hd__a2bb2o_1
XFILLER_32_85 VPWR VGND VPWR VGND sky130_ef_sc_hd__decap_12
XFILLER_43_281 VGND VGND VPWR VPWR sky130_fd_sc_hd__decap_4
XTAP_TAPCELL_ROW_13_184 VGND VPWR sky130_fd_sc_hd__tapvpwrvgnd_1
X_1019_ _0346_ _0342_ _0344_ VGND VGND VPWR VPWR _0350_ sky130_fd_sc_hd__a21oi_2
Xrebuffer224 net48 VGND VGND VPWR VPWR net359 sky130_fd_sc_hd__dlygate4sd1_1
Xrebuffer246 _0291_ VGND VGND VPWR VPWR net381 sky130_fd_sc_hd__dlygate4sd1_1
XPHY_EDGE_ROW_36_Left_89 VGND VGND VPWR VPWR sky130_fd_sc_hd__decap_3
XFILLER_40_295 VGND VGND VPWR VPWR sky130_fd_sc_hd__fill_1
XFILLER_4_141 VPWR VGND VPWR VGND sky130_ef_sc_hd__decap_12
X_1370_ net194 net84 VGND VGND VPWR VPWR _0063_ sky130_fd_sc_hd__and2_1
XTAP_TAPCELL_ROW_18_210 VGND VPWR sky130_fd_sc_hd__tapvpwrvgnd_1
XFILLER_31_240 VGND VGND VPWR VPWR sky130_fd_sc_hd__fill_1
XFILLER_16_281 VPWR VGND VPWR VGND sky130_ef_sc_hd__decap_12
XFILLER_48_29 VPWR VGND VPWR VGND sky130_ef_sc_hd__decap_12
XFILLER_22_251 VGND VGND VPWR VPWR sky130_fd_sc_hd__fill_1
XTAP_TAPCELL_ROW_24_246 VGND VPWR sky130_fd_sc_hd__tapvpwrvgnd_1
Xfanout77 v_pipe VGND VGND VPWR VPWR net77 sky130_fd_sc_hd__buf_2
Xfanout88 _0082_ VGND VGND VPWR VPWR net88 sky130_fd_sc_hd__clkbuf_2
XTAP_TAPCELL_ROW_32_290 VGND VPWR sky130_fd_sc_hd__tapvpwrvgnd_1
Xfanout99 net100 VGND VGND VPWR VPWR net99 sky130_fd_sc_hd__buf_6
XFILLER_49_137 VGND VGND VPWR VPWR sky130_fd_sc_hd__fill_2
XFILLER_8_3 VPWR VGND VPWR VGND sky130_ef_sc_hd__decap_12
XFILLER_1_111 VGND VGND VPWR VPWR sky130_fd_sc_hd__fill_1
X_0870_ net392 net417 _0218_ net82 _0220_ VGND VGND VPWR VPWR _0028_ sky130_fd_sc_hd__a311oi_1
XFILLER_9_222 VGND VGND VPWR VPWR sky130_fd_sc_hd__fill_2
XFILLER_13_262 VPWR VGND VPWR VGND sky130_ef_sc_hd__decap_12
X_1422_ clknet_3_5__leaf_clk _0048_ VGND VGND VPWR VPWR product_reg\[5\] sky130_fd_sc_hd__dfxtp_1
X_1353_ _0653_ _0654_ _0672_ _0675_ VGND VGND VPWR VPWR _0676_ sky130_fd_sc_hd__a31oi_1
X_1284_ net118 net94 VGND VGND VPWR VPWR _0610_ sky130_fd_sc_hd__nand2_1
X_0999_ net92 net131 net97 net101 VGND VGND VPWR VPWR _0330_ sky130_fd_sc_hd__and4_1
XTAP_TAPCELL_ROW_21_227 VGND VPWR sky130_fd_sc_hd__tapvpwrvgnd_1
XFILLER_46_118 VGND VGND VPWR VPWR sky130_fd_sc_hd__fill_1
XFILLER_24_75 VGND VGND VPWR VPWR sky130_fd_sc_hd__decap_8
XPHY_EDGE_ROW_39_Left_92 VGND VGND VPWR VPWR sky130_fd_sc_hd__decap_3
XTAP_TAPCELL_ROW_43_352 VGND VPWR sky130_fd_sc_hd__tapvpwrvgnd_1
XTAP_TAPCELL_ROW_35_308 VGND VPWR sky130_fd_sc_hd__tapvpwrvgnd_1
XFILLER_1_57 VPWR VGND VPWR VGND sky130_ef_sc_hd__decap_12
XPHY_EDGE_ROW_23_Left_76 VGND VGND VPWR VPWR sky130_fd_sc_hd__decap_3
X_0853_ net71 net49 net50 _0204_ net391 VGND VGND VPWR VPWR _0209_ sky130_fd_sc_hd__a41oi_2
X_0922_ _0250_ _0251_ _0252_ _0245_ _0253_ VGND VGND VPWR VPWR _0256_ sky130_fd_sc_hd__a311o_1
X_1405_ clknet_3_3__leaf_clk _0031_ VGND VGND VPWR VPWR net60 sky130_fd_sc_hd__dfxtp_1
X_0784_ product_reg\[10\] net38 VGND VGND VPWR VPWR _0152_ sky130_fd_sc_hd__or2_1
Xinput1 a_in[0] VGND VGND VPWR VPWR net1 sky130_fd_sc_hd__buf_1
X_1198_ net125 net96 net99 net121 VGND VGND VPWR VPWR _0526_ sky130_fd_sc_hd__a22o_1
X_1336_ net8 net114 _0632_ _0659_ VGND VGND VPWR VPWR _0660_ sky130_fd_sc_hd__a31o_1
X_1267_ _0590_ _0589_ _0588_ VGND VGND VPWR VPWR _0594_ sky130_fd_sc_hd__nand3_1
XFILLER_51_121 VGND VGND VPWR VPWR sky130_fd_sc_hd__decap_4
XFILLER_3_217 VGND VGND VPWR VPWR sky130_fd_sc_hd__decap_6
XFILLER_10_11 VGND VGND VPWR VPWR sky130_fd_sc_hd__fill_1
XFILLER_51_95 VGND VGND VPWR VPWR sky130_fd_sc_hd__fill_1
XFILLER_51_51 VGND VGND VPWR VPWR sky130_fd_sc_hd__decap_4
XFILLER_42_187 VGND VGND VPWR VPWR sky130_fd_sc_hd__decap_8
XTAP_TAPCELL_ROW_40_333 VGND VPWR sky130_fd_sc_hd__tapvpwrvgnd_1
X_1121_ product_reg\[7\] _0232_ _0450_ _0449_ VGND VGND VPWR VPWR _0050_ sky130_fd_sc_hd__a22o_1
X_1052_ net110 net117 VGND VGND VPWR VPWR _0382_ sky130_fd_sc_hd__nand2_1
X_0836_ net396 net370 net86 VGND VGND VPWR VPWR _0198_ sky130_fd_sc_hd__o21ai_2
X_0767_ _0135_ _0136_ net77 _0137_ VGND VGND VPWR VPWR _0008_ sky130_fd_sc_hd__a31oi_1
X_0905_ _0074_ _0075_ _0237_ _0238_ VGND VGND VPWR VPWR _0240_ sky130_fd_sc_hd__o22a_1
XFILLER_0_209 VPWR VGND VPWR VGND sky130_ef_sc_hd__decap_12
X_0698_ net119 VGND VGND VPWR VPWR _0078_ sky130_fd_sc_hd__clkinv_4
X_1319_ _0631_ _0641_ _0642_ VGND VGND VPWR VPWR _0644_ sky130_fd_sc_hd__and3_1
XFILLER_8_309 VGND VGND VPWR VPWR sky130_fd_sc_hd__fill_2
XFILLER_21_54 VGND VGND VPWR VPWR sky130_fd_sc_hd__fill_2
XFILLER_47_279 VGND VGND VPWR VPWR sky130_fd_sc_hd__fill_1
XFILLER_47_235 VGND VGND VPWR VPWR sky130_fd_sc_hd__decap_8
Xmax_cap74 _0339_ VGND VGND VPWR VPWR net74 sky130_fd_sc_hd__buf_6
XFILLER_15_110 VGND VGND VPWR VPWR sky130_fd_sc_hd__fill_2
XFILLER_23_3 VGND VGND VPWR VPWR sky130_fd_sc_hd__fill_1
X_1104_ _0388_ _0389_ net174 _0429_ VGND VGND VPWR VPWR _0434_ sky130_fd_sc_hd__o22ai_2
X_1035_ _0075_ _0079_ _0291_ _0363_ VGND VGND VPWR VPWR _0366_ sky130_fd_sc_hd__or4_4
X_0819_ _0173_ net40 product_reg\[12\] _0174_ VGND VGND VPWR VPWR _0183_ sky130_fd_sc_hd__a31o_1
XPHY_EDGE_ROW_10_Left_63 VGND VGND VPWR VPWR sky130_fd_sc_hd__decap_3
XFILLER_32_97 VGND VGND VPWR VPWR sky130_fd_sc_hd__decap_8
XFILLER_32_20 VGND VGND VPWR VPWR sky130_fd_sc_hd__decap_8
XFILLER_8_117 VGND VGND VPWR VPWR sky130_fd_sc_hd__decap_3
XFILLER_4_301 VGND VGND VPWR VPWR sky130_fd_sc_hd__decap_6
XFILLER_12_168 VGND VGND VPWR VPWR sky130_fd_sc_hd__decap_4
XTAP_TAPCELL_ROW_7_150 VGND VPWR sky130_fd_sc_hd__tapvpwrvgnd_1
XPHY_EDGE_ROW_9_Right_9 VGND VGND VPWR VPWR sky130_fd_sc_hd__decap_3
XTAP_TAPCELL_ROW_13_185 VGND VPWR sky130_fd_sc_hd__tapvpwrvgnd_1
X_1018_ _0341_ _0347_ _0345_ VGND VGND VPWR VPWR _0349_ sky130_fd_sc_hd__o21ai_1
Xrebuffer225 net48 VGND VGND VPWR VPWR net360 sky130_fd_sc_hd__dlygate4sd1_1
Xrebuffer247 _0292_ VGND VGND VPWR VPWR net382 sky130_fd_sc_hd__dlygate4sd1_1
XFILLER_49_308 VGND VGND VPWR VPWR sky130_fd_sc_hd__decap_3
XFILLER_17_249 VPWR VGND VPWR VGND sky130_ef_sc_hd__decap_12
XFILLER_27_53 VGND VGND VPWR VPWR sky130_fd_sc_hd__decap_3
XFILLER_27_64 VGND VGND VPWR VPWR sky130_fd_sc_hd__decap_4
XFILLER_4_153 VPWR VGND VPWR VGND sky130_ef_sc_hd__decap_12
XTAP_TAPCELL_ROW_10_166 VGND VPWR sky130_fd_sc_hd__tapvpwrvgnd_1
XFILLER_4_197 VPWR VGND VPWR VGND sky130_ef_sc_hd__decap_12
XFILLER_16_293 VPWR VGND VPWR VGND sky130_ef_sc_hd__decap_12
XTAP_TAPCELL_ROW_18_211 VGND VPWR sky130_fd_sc_hd__tapvpwrvgnd_1
XFILLER_23_219 VGND VGND VPWR VPWR sky130_fd_sc_hd__decap_4
XTAP_TAPCELL_ROW_24_247 VGND VPWR sky130_fd_sc_hd__tapvpwrvgnd_1
Xfanout78 net79 VGND VGND VPWR VPWR net78 sky130_fd_sc_hd__buf_2
Xfanout89 _0081_ VGND VGND VPWR VPWR net89 sky130_fd_sc_hd__clkbuf_4
XTAP_TAPCELL_ROW_32_291 VGND VPWR sky130_fd_sc_hd__tapvpwrvgnd_1
XFILLER_13_66 VGND VGND VPWR VPWR sky130_fd_sc_hd__fill_1
XFILLER_1_167 VGND VGND VPWR VPWR sky130_fd_sc_hd__fill_1
XFILLER_38_85 VPWR VGND VPWR VGND sky130_ef_sc_hd__decap_12
XFILLER_13_274 VGND VGND VPWR VPWR sky130_fd_sc_hd__decap_6
X_1421_ clknet_3_4__leaf_clk _0047_ VGND VGND VPWR VPWR product_reg\[4\] sky130_fd_sc_hd__dfxtp_1
X_1352_ _0674_ VGND VGND VPWR VPWR _0675_ sky130_fd_sc_hd__inv_2
X_1283_ _0606_ _0607_ net102 net114 VGND VGND VPWR VPWR _0609_ sky130_fd_sc_hd__nand4_4
X_0998_ net130 net95 VGND VGND VPWR VPWR _0329_ sky130_fd_sc_hd__nand2_2
XTAP_TAPCELL_ROW_21_228 VGND VPWR sky130_fd_sc_hd__tapvpwrvgnd_1
XTAP_TAPCELL_ROW_52_397 VGND VPWR sky130_fd_sc_hd__tapvpwrvgnd_1
XFILLER_40_42 VGND VGND VPWR VPWR sky130_fd_sc_hd__decap_4
XFILLER_49_73 VGND VGND VPWR VPWR sky130_fd_sc_hd__fill_1
XFILLER_49_51 VGND VGND VPWR VPWR sky130_fd_sc_hd__decap_4
XFILLER_1_69 VPWR VGND VPWR VGND sky130_ef_sc_hd__decap_12
X_0921_ _0250_ _0251_ _0252_ VGND VGND VPWR VPWR _0255_ sky130_fd_sc_hd__nand3_1
X_0852_ _0208_ _0205_ net86 _0207_ VGND VGND VPWR VPWR _0022_ sky130_fd_sc_hd__o211a_1
X_0783_ product_reg\[10\] net38 VGND VGND VPWR VPWR _0151_ sky130_fd_sc_hd__nand2_2
X_1404_ clknet_3_6__leaf_clk _0030_ VGND VGND VPWR VPWR net58 sky130_fd_sc_hd__dfxtp_1
XFILLER_5_281 VPWR VGND VPWR VGND sky130_ef_sc_hd__decap_12
X_1335_ net116 net94 net114 net98 VGND VGND VPWR VPWR _0659_ sky130_fd_sc_hd__a22oi_1
X_1266_ _0590_ _0589_ _0588_ VGND VGND VPWR VPWR _0593_ sky130_fd_sc_hd__and3_1
Xinput2 a_in[1] VGND VGND VPWR VPWR net2 sky130_fd_sc_hd__clkbuf_1
X_1197_ net125 net96 net99 net121 VGND VGND VPWR VPWR _0525_ sky130_fd_sc_hd__a22oi_4
XFILLER_51_166 VGND VGND VPWR VPWR sky130_fd_sc_hd__fill_2
XPHY_EDGE_ROW_40_Left_93 VGND VGND VPWR VPWR sky130_fd_sc_hd__decap_3
XFILLER_10_89 VGND VGND VPWR VPWR sky130_fd_sc_hd__fill_1
XFILLER_27_130 VGND VGND VPWR VPWR sky130_fd_sc_hd__fill_2
XTAP_TAPCELL_ROW_40_334 VGND VPWR sky130_fd_sc_hd__tapvpwrvgnd_1
XFILLER_2_251 VGND VGND VPWR VPWR sky130_fd_sc_hd__fill_1
X_1120_ _0379_ _0448_ _0086_ VGND VGND VPWR VPWR _0450_ sky130_fd_sc_hd__a21oi_1
XFILLER_18_141 VGND VGND VPWR VPWR sky130_fd_sc_hd__decap_3
XFILLER_18_152 VGND VGND VPWR VPWR sky130_fd_sc_hd__fill_1
X_1051_ _0351_ _0352_ _0356_ _0369_ _0361_ VGND VGND VPWR VPWR _0381_ sky130_fd_sc_hd__a32oi_4
X_0904_ net91 net108 net112 net132 VGND VGND VPWR VPWR _0239_ sky130_fd_sc_hd__a22o_1
X_0835_ _0182_ _0195_ net77 _0193_ VGND VGND VPWR VPWR _0197_ sky130_fd_sc_hd__o211a_1
XPHY_EDGE_ROW_47_Left_100 VGND VGND VPWR VPWR sky130_fd_sc_hd__decap_3
X_0766_ _0070_ _0071_ net17 net18 VGND VGND VPWR VPWR _0137_ sky130_fd_sc_hd__a211o_1
X_0697_ net99 VGND VGND VPWR VPWR _0077_ sky130_fd_sc_hd__clkinv_4
X_1318_ _0641_ _0642_ _0631_ VGND VGND VPWR VPWR _0643_ sky130_fd_sc_hd__a21oi_1
X_1249_ net99 net118 VGND VGND VPWR VPWR _0576_ sky130_fd_sc_hd__nand2_2
XFILLER_46_41 VGND VGND VPWR VPWR sky130_fd_sc_hd__decap_8
XFILLER_15_133 VGND VGND VPWR VPWR sky130_fd_sc_hd__fill_1
Xmax_cap75 _0242_ VGND VGND VPWR VPWR net75 sky130_fd_sc_hd__clkbuf_2
XFILLER_7_57 VGND VGND VPWR VPWR sky130_fd_sc_hd__decap_6
XFILLER_16_3 VGND VGND VPWR VPWR sky130_fd_sc_hd__fill_1
X_1103_ _0390_ _0391_ _0428_ _0430_ VGND VGND VPWR VPWR _0433_ sky130_fd_sc_hd__o211ai_2
X_1034_ _0075_ _0078_ _0291_ _0290_ VGND VGND VPWR VPWR _0365_ sky130_fd_sc_hd__o31a_1
XFILLER_21_147 VGND VGND VPWR VPWR sky130_fd_sc_hd__fill_1
X_0818_ _0167_ _0169_ _0181_ VGND VGND VPWR VPWR _0182_ sky130_fd_sc_hd__a21boi_4
X_0749_ _0117_ _0120_ _0121_ VGND VGND VPWR VPWR _0122_ sky130_fd_sc_hd__a21oi_1
XFILLER_52_250 VGND VGND VPWR VPWR sky130_fd_sc_hd__fill_2
XFILLER_32_10 VGND VGND VPWR VPWR sky130_fd_sc_hd__decap_6
XTAP_TAPCELL_ROW_7_151 VGND VPWR sky130_fd_sc_hd__tapvpwrvgnd_1
XTAP_TAPCELL_ROW_13_186 VGND VPWR sky130_fd_sc_hd__tapvpwrvgnd_1
XFILLER_26_228 VGND VGND VPWR VPWR sky130_fd_sc_hd__fill_1
X_1017_ _0342_ _0343_ net110 net119 VGND VGND VPWR VPWR _0348_ sky130_fd_sc_hd__and4_2
XFILLER_26_239 VPWR VGND VPWR VGND sky130_ef_sc_hd__decap_12
Xrebuffer226 _0126_ VGND VGND VPWR VPWR net361 sky130_fd_sc_hd__dlygate4sd1_1
Xrebuffer237 product_reg\[1\] VGND VGND VPWR VPWR net372 sky130_fd_sc_hd__dlygate4sd1_1
Xrebuffer248 _0363_ VGND VGND VPWR VPWR net383 sky130_fd_sc_hd__dlygate4sd1_1
XFILLER_1_305 VGND VGND VPWR VPWR sky130_fd_sc_hd__decap_6
XFILLER_27_10 VGND VGND VPWR VPWR sky130_fd_sc_hd__fill_2
XFILLER_27_32 VGND VGND VPWR VPWR sky130_fd_sc_hd__fill_2
XFILLER_40_253 VGND VGND VPWR VPWR sky130_fd_sc_hd__fill_2
XFILLER_25_261 VPWR VGND VPWR VGND sky130_ef_sc_hd__decap_12
XFILLER_4_165 VPWR VGND VPWR VGND sky130_ef_sc_hd__decap_12
XFILLER_4_121 VPWR VGND VPWR VGND sky130_ef_sc_hd__decap_12
XTAP_TAPCELL_ROW_10_167 VGND VPWR sky130_fd_sc_hd__tapvpwrvgnd_1
XTAP_TAPCELL_ROW_18_212 VGND VPWR sky130_fd_sc_hd__tapvpwrvgnd_1
XTAP_TAPCELL_ROW_49_381 VGND VPWR sky130_fd_sc_hd__tapvpwrvgnd_1
XTAP_TAPCELL_ROW_32_292 VGND VPWR sky130_fd_sc_hd__tapvpwrvgnd_1
XFILLER_13_45 VGND VGND VPWR VPWR sky130_fd_sc_hd__decap_8
XFILLER_22_231 VGND VGND VPWR VPWR sky130_fd_sc_hd__decap_6
XFILLER_22_253 VPWR VGND VPWR VGND sky130_ef_sc_hd__decap_12
XFILLER_22_297 VGND VGND VPWR VPWR sky130_fd_sc_hd__decap_3
XTAP_TAPCELL_ROW_24_248 VGND VPWR sky130_fd_sc_hd__tapvpwrvgnd_1
Xfanout79 v_pipe VGND VGND VPWR VPWR net79 sky130_fd_sc_hd__buf_2
XFILLER_1_113 VPWR VGND VPWR VGND sky130_ef_sc_hd__decap_12
XFILLER_49_106 VGND VGND VPWR VPWR sky130_fd_sc_hd__fill_1
XFILLER_38_97 VGND VGND VPWR VPWR sky130_fd_sc_hd__fill_1
XFILLER_9_202 VPWR VGND VPWR VGND sky130_ef_sc_hd__decap_12
XFILLER_9_279 VGND VGND VPWR VPWR sky130_fd_sc_hd__fill_1
X_1351_ _0648_ _0666_ _0665_ VGND VGND VPWR VPWR _0674_ sky130_fd_sc_hd__a21oi_2
X_1420_ clknet_3_7__leaf_clk _0046_ VGND VGND VPWR VPWR product_reg\[3\] sky130_fd_sc_hd__dfxtp_1
XFILLER_48_183 VPWR VGND VPWR VGND sky130_ef_sc_hd__decap_12
X_1282_ _0606_ _0607_ _0076_ net89 VGND VGND VPWR VPWR _0608_ sky130_fd_sc_hd__o2bb2ai_2
XTAP_TAPCELL_ROW_21_229 VGND VPWR sky130_fd_sc_hd__tapvpwrvgnd_1
X_0997_ net92 net97 net101 net131 VGND VGND VPWR VPWR _0328_ sky130_fd_sc_hd__a22o_1
XFILLER_39_150 VGND VGND VPWR VPWR sky130_fd_sc_hd__fill_2
XFILLER_27_301 VGND VGND VPWR VPWR sky130_fd_sc_hd__fill_2
XFILLER_39_183 VPWR VGND VPWR VGND sky130_ef_sc_hd__decap_12
XFILLER_39_172 VGND VGND VPWR VPWR sky130_fd_sc_hd__fill_1
XTAP_TAPCELL_ROW_52_398 VGND VPWR sky130_fd_sc_hd__tapvpwrvgnd_1
XFILLER_40_76 VGND VGND VPWR VPWR sky130_fd_sc_hd__fill_1
XFILLER_45_120 VGND VGND VPWR VPWR sky130_fd_sc_hd__fill_1
XFILLER_1_15 VPWR VGND VPWR VGND sky130_ef_sc_hd__decap_12
X_0920_ _0250_ _0251_ _0252_ VGND VGND VPWR VPWR _0254_ sky130_fd_sc_hd__a21o_1
X_0851_ net50 net49 VGND VGND VPWR VPWR _0208_ sky130_fd_sc_hd__nand2_1
X_0782_ _0148_ _0149_ _0150_ net83 VGND VGND VPWR VPWR _0010_ sky130_fd_sc_hd__o211a_1
X_1403_ clknet_3_6__leaf_clk _0029_ VGND VGND VPWR VPWR net57 sky130_fd_sc_hd__dfxtp_1
XFILLER_46_3 VPWR VGND VPWR VGND sky130_ef_sc_hd__decap_12
X_1265_ _0588_ _0589_ _0590_ VGND VGND VPWR VPWR _0592_ sky130_fd_sc_hd__a21o_1
XFILLER_5_293 VPWR VGND VPWR VGND sky130_ef_sc_hd__decap_12
XPHY_EDGE_ROW_18_Right_18 VGND VGND VPWR VPWR sky130_fd_sc_hd__decap_3
X_1334_ _0077_ net89 _0635_ _0611_ _0079_ VGND VGND VPWR VPWR _0658_ sky130_fd_sc_hd__o32ai_2
XFILLER_36_197 VGND VGND VPWR VPWR sky130_fd_sc_hd__decap_6
Xinput3 a_in[2] VGND VGND VPWR VPWR net3 sky130_fd_sc_hd__clkbuf_1
X_1196_ net102 net118 VGND VGND VPWR VPWR _0524_ sky130_fd_sc_hd__nand2_1
XPHY_EDGE_ROW_27_Right_27 VGND VGND VPWR VPWR sky130_fd_sc_hd__decap_3
XPHY_EDGE_ROW_36_Right_36 VGND VGND VPWR VPWR sky130_fd_sc_hd__decap_3
XPHY_EDGE_ROW_45_Right_45 VGND VGND VPWR VPWR sky130_fd_sc_hd__decap_3
XTAP_TAPCELL_ROW_40_335 VGND VPWR sky130_fd_sc_hd__tapvpwrvgnd_1
XFILLER_35_65 VPWR VGND VPWR VGND sky130_ef_sc_hd__decap_12
XFILLER_35_32 VGND VGND VPWR VPWR sky130_fd_sc_hd__decap_8
XFILLER_18_197 VGND VGND VPWR VPWR sky130_fd_sc_hd__decap_4
X_1050_ _0353_ _0355_ _0357_ _0368_ VGND VGND VPWR VPWR _0380_ sky130_fd_sc_hd__a31oi_2
X_0834_ _0182_ _0195_ _0193_ VGND VGND VPWR VPWR _0196_ sky130_fd_sc_hd__o21a_4
XFILLER_33_156 VGND VGND VPWR VPWR sky130_fd_sc_hd__fill_2
X_0903_ net91 net108 net112 net132 VGND VGND VPWR VPWR _0238_ sky130_fd_sc_hd__a22oi_1
X_0765_ _0131_ _0133_ _0134_ VGND VGND VPWR VPWR _0136_ sky130_fd_sc_hd__o21ai_1
X_0696_ net102 VGND VGND VPWR VPWR _0076_ sky130_fd_sc_hd__clkinv_4
X_1317_ _0638_ _0639_ _0614_ _0609_ VGND VGND VPWR VPWR _0642_ sky130_fd_sc_hd__a22o_1
X_1248_ _0573_ net114 net104 _0572_ VGND VGND VPWR VPWR _0575_ sky130_fd_sc_hd__nand4_2
XFILLER_12_307 VGND VGND VPWR VPWR sky130_fd_sc_hd__fill_1
X_1179_ _0075_ _0079_ net381 net383 _0437_ VGND VGND VPWR VPWR _0508_ sky130_fd_sc_hd__o41ai_4
XFILLER_47_248 VPWR VGND VPWR VGND sky130_ef_sc_hd__decap_12
XFILLER_7_47 VGND VGND VPWR VPWR sky130_fd_sc_hd__decap_3
X_1102_ _0390_ _0391_ net175 _0429_ VGND VGND VPWR VPWR _0432_ sky130_fd_sc_hd__o22ai_2
X_1033_ net382 net120 net134 net386 VGND VGND VPWR VPWR _0364_ sky130_fd_sc_hd__a31o_1
X_0817_ _0165_ _0173_ _0175_ VGND VGND VPWR VPWR _0181_ sky130_fd_sc_hd__and3_1
XFILLER_21_137 VGND VGND VPWR VPWR sky130_fd_sc_hd__fill_1
X_0748_ _0117_ _0120_ net77 VGND VGND VPWR VPWR _0121_ sky130_fd_sc_hd__o21ai_1
XFILLER_29_204 VGND VGND VPWR VPWR sky130_fd_sc_hd__decap_6
XPHY_EDGE_ROW_0_Right_0 VGND VGND VPWR VPWR sky130_fd_sc_hd__decap_3
XFILLER_20_170 VGND VGND VPWR VPWR sky130_fd_sc_hd__decap_8
XTAP_TAPCELL_ROW_7_152 VGND VPWR sky130_fd_sc_hd__tapvpwrvgnd_1
XTAP_TAPCELL_ROW_13_187 VGND VPWR sky130_fd_sc_hd__tapvpwrvgnd_1
XFILLER_19_270 VGND VGND VPWR VPWR sky130_fd_sc_hd__decap_8
XFILLER_19_281 VPWR VGND VPWR VGND sky130_ef_sc_hd__decap_12
X_1016_ net105 net109 net126 net123 _0340_ VGND VGND VPWR VPWR _0347_ sky130_fd_sc_hd__a41o_1
Xrebuffer227 net361 VGND VGND VPWR VPWR net362 sky130_fd_sc_hd__dlygate4sd1_1
Xrebuffer238 net374 VGND VGND VPWR VPWR net373 sky130_fd_sc_hd__dlygate4sd1_1
Xrebuffer249 _0273_ VGND VGND VPWR VPWR net384 sky130_fd_sc_hd__buf_1
XTAP_TAPCELL_ROW_4_133 VGND VPWR sky130_fd_sc_hd__tapvpwrvgnd_1
XFILLER_17_229 VGND VGND VPWR VPWR sky130_fd_sc_hd__fill_2
XFILLER_25_273 VGND VGND VPWR VPWR sky130_fd_sc_hd__decap_4
XFILLER_27_44 VGND VGND VPWR VPWR sky130_fd_sc_hd__decap_4
XFILLER_43_54 VGND VGND VPWR VPWR sky130_fd_sc_hd__fill_2
Xclone42 net97 VGND VGND VPWR VPWR net177 sky130_fd_sc_hd__buf_6
XFILLER_4_177 VPWR VGND VPWR VGND sky130_ef_sc_hd__decap_12
XFILLER_4_133 VGND VGND VPWR VPWR sky130_fd_sc_hd__decap_6
XFILLER_4_15 VPWR VGND VPWR VGND sky130_ef_sc_hd__decap_12
XTAP_TAPCELL_ROW_10_168 VGND VPWR sky130_fd_sc_hd__tapvpwrvgnd_1
XTAP_TAPCELL_ROW_18_213 VGND VPWR sky130_fd_sc_hd__tapvpwrvgnd_1
XFILLER_31_232 VGND VGND VPWR VPWR sky130_fd_sc_hd__fill_1
XTAP_TAPCELL_ROW_49_382 VGND VPWR sky130_fd_sc_hd__tapvpwrvgnd_1
XFILLER_22_265 VPWR VGND VPWR VGND sky130_ef_sc_hd__decap_12
XFILLER_1_125 VPWR VGND VPWR VGND sky130_ef_sc_hd__decap_12
XFILLER_1_169 VPWR VGND VPWR VGND sky130_ef_sc_hd__decap_12
XFILLER_9_214 VGND VGND VPWR VPWR sky130_fd_sc_hd__decap_8
XFILLER_9_225 VPWR VGND VPWR VGND sky130_ef_sc_hd__decap_12
XFILLER_13_221 VGND VGND VPWR VPWR sky130_fd_sc_hd__decap_3
X_1350_ _0653_ _0654_ _0672_ VGND VGND VPWR VPWR _0673_ sky130_fd_sc_hd__nand3_1
X_1281_ _0605_ net116 net153 _0578_ VGND VGND VPWR VPWR _0607_ sky130_fd_sc_hd__nand4_4
XFILLER_51_305 VGND VGND VPWR VPWR sky130_fd_sc_hd__fill_2
XFILLER_48_195 VGND VGND VPWR VPWR sky130_fd_sc_hd__fill_1
X_0996_ net92 net97 net131 net155 VGND VGND VPWR VPWR _0327_ sky130_fd_sc_hd__a22oi_4
XFILLER_39_195 VGND VGND VPWR VPWR sky130_fd_sc_hd__decap_4
XTAP_TAPCELL_ROW_52_399 VGND VPWR sky130_fd_sc_hd__tapvpwrvgnd_1
XFILLER_40_11 VPWR VGND VPWR VGND sky130_ef_sc_hd__decap_12
Xhold280 net47 VGND VGND VPWR VPWR net415 sky130_fd_sc_hd__dlygate4sd3_1
XFILLER_40_99 VGND VGND VPWR VPWR sky130_fd_sc_hd__fill_1
XFILLER_6_3 VPWR VGND VPWR VGND sky130_ef_sc_hd__decap_12
XFILLER_45_154 VPWR VGND VPWR VGND sky130_ef_sc_hd__decap_12
XFILLER_1_27 VPWR VGND VPWR VGND sky130_ef_sc_hd__decap_12
X_0850_ net49 net71 _0204_ net50 VGND VGND VPWR VPWR _0207_ sky130_fd_sc_hd__a31o_1
X_0781_ net79 net68 VGND VGND VPWR VPWR _0150_ sky130_fd_sc_hd__or2_1
X_1402_ clknet_3_6__leaf_clk _0028_ VGND VGND VPWR VPWR net56 sky130_fd_sc_hd__dfxtp_1
XFILLER_5_261 VPWR VGND VPWR VGND sky130_ef_sc_hd__decap_12
X_1333_ net390 _0232_ _0657_ _0086_ VGND VGND VPWR VPWR _0055_ sky130_fd_sc_hd__o2bb2ai_1
X_1264_ _0588_ _0589_ _0590_ VGND VGND VPWR VPWR _0591_ sky130_fd_sc_hd__a21oi_1
Xinput4 a_in[3] VGND VGND VPWR VPWR net4 sky130_fd_sc_hd__clkbuf_1
XFILLER_36_154 VGND VGND VPWR VPWR sky130_fd_sc_hd__decap_3
XFILLER_36_121 VGND VGND VPWR VPWR sky130_fd_sc_hd__fill_2
XTAP_TAPCELL_ROW_34_300 VGND VPWR sky130_fd_sc_hd__tapvpwrvgnd_1
X_1195_ _0329_ net94 net128 VGND VGND VPWR VPWR _0523_ sky130_fd_sc_hd__and3_1
X_0979_ net377 _0309_ net379 VGND VGND VPWR VPWR _0311_ sky130_fd_sc_hd__nand3b_4
XFILLER_10_36 VGND VGND VPWR VPWR sky130_fd_sc_hd__decap_6
XFILLER_15_305 VGND VGND VPWR VPWR sky130_fd_sc_hd__decap_6
XTAP_TAPCELL_ROW_40_336 VGND VPWR sky130_fd_sc_hd__tapvpwrvgnd_1
XFILLER_35_77 VPWR VGND VPWR VGND sky130_ef_sc_hd__decap_12
XFILLER_51_76 VGND VGND VPWR VPWR sky130_fd_sc_hd__decap_3
XFILLER_2_253 VPWR VGND VPWR VGND sky130_ef_sc_hd__decap_12
X_0833_ product_reg\[15\] net43 _0183_ _0194_ VGND VGND VPWR VPWR _0195_ sky130_fd_sc_hd__a211o_1
X_0902_ net91 net132 net108 net111 VGND VGND VPWR VPWR _0237_ sky130_fd_sc_hd__and4_1
X_0764_ _0131_ _0133_ _0134_ VGND VGND VPWR VPWR _0135_ sky130_fd_sc_hd__or3_1
X_0695_ net134 VGND VGND VPWR VPWR _0075_ sky130_fd_sc_hd__inv_2
X_1247_ net104 net114 _0572_ _0573_ VGND VGND VPWR VPWR _0574_ sky130_fd_sc_hd__a22o_1
X_1178_ _0384_ _0502_ _0494_ _0499_ net150 VGND VGND VPWR VPWR _0507_ sky130_fd_sc_hd__o221ai_4
X_1316_ _0614_ _0638_ _0639_ _0609_ VGND VGND VPWR VPWR _0641_ sky130_fd_sc_hd__nand4_1
XFILLER_21_57 VGND VGND VPWR VPWR sky130_fd_sc_hd__decap_4
XFILLER_15_113 VPWR VGND VPWR VGND sky130_ef_sc_hd__decap_12
XFILLER_7_15 VPWR VGND VPWR VGND sky130_ef_sc_hd__decap_12
XFILLER_30_105 VGND VGND VPWR VPWR sky130_fd_sc_hd__decap_6
X_1032_ _0075_ _0078_ _0290_ VGND VGND VPWR VPWR _0363_ sky130_fd_sc_hd__o21a_1
X_1101_ _0388_ _0389_ _0428_ _0430_ VGND VGND VPWR VPWR _0431_ sky130_fd_sc_hd__o211ai_4
XFILLER_14_190 VGND VGND VPWR VPWR sky130_fd_sc_hd__decap_6
X_0816_ product_reg\[14\] net42 VGND VGND VPWR VPWR _0180_ sky130_fd_sc_hd__nand2_1
X_0747_ _0118_ _0119_ VGND VGND VPWR VPWR _0120_ sky130_fd_sc_hd__and2_1
XFILLER_29_216 VGND VGND VPWR VPWR sky130_fd_sc_hd__decap_8
XFILLER_20_193 VGND VGND VPWR VPWR sky130_fd_sc_hd__decap_3
XTAP_TAPCELL_ROW_7_153 VGND VPWR sky130_fd_sc_hd__tapvpwrvgnd_1
XFILLER_43_285 VGND VGND VPWR VPWR sky130_fd_sc_hd__fill_1
XFILLER_43_274 VGND VGND VPWR VPWR sky130_fd_sc_hd__decap_6
XFILLER_7_175 VPWR VGND VPWR VGND sky130_ef_sc_hd__decap_12
XFILLER_34_241 VGND VGND VPWR VPWR sky130_fd_sc_hd__decap_8
X_1015_ _0343_ net119 net110 VGND VGND VPWR VPWR _0346_ sky130_fd_sc_hd__and3_1
XFILLER_19_293 VPWR VGND VPWR VGND sky130_ef_sc_hd__decap_12
XFILLER_34_296 VGND VGND VPWR VPWR sky130_fd_sc_hd__fill_2
XPHY_EDGE_ROW_14_Left_67 VGND VGND VPWR VPWR sky130_fd_sc_hd__decap_3
Xrebuffer228 net365 VGND VGND VPWR VPWR net363 sky130_fd_sc_hd__clkbuf_2
Xrebuffer239 product_reg\[1\] VGND VGND VPWR VPWR net374 sky130_fd_sc_hd__dlygate4sd1_1
XTAP_TAPCELL_ROW_4_134 VGND VPWR sky130_fd_sc_hd__tapvpwrvgnd_1
XFILLER_40_233 VGND VGND VPWR VPWR sky130_fd_sc_hd__decap_3
XFILLER_40_200 VGND VGND VPWR VPWR sky130_fd_sc_hd__fill_1
XFILLER_27_78 VGND VGND VPWR VPWR sky130_fd_sc_hd__decap_8
XTAP_TAPCELL_ROW_10_169 VGND VPWR sky130_fd_sc_hd__tapvpwrvgnd_1
XFILLER_4_189 VGND VGND VPWR VPWR sky130_fd_sc_hd__decap_6
XFILLER_4_27 VGND VGND VPWR VPWR sky130_fd_sc_hd__fill_1
XTAP_TAPCELL_ROW_18_214 VGND VPWR sky130_fd_sc_hd__tapvpwrvgnd_1
XTAP_TAPCELL_ROW_49_383 VGND VPWR sky130_fd_sc_hd__tapvpwrvgnd_1
XFILLER_22_277 VPWR VGND VPWR VGND sky130_ef_sc_hd__decap_12
XFILLER_1_137 VPWR VGND VPWR VGND sky130_ef_sc_hd__decap_12
XFILLER_9_237 VPWR VGND VPWR VGND sky130_ef_sc_hd__decap_12
XFILLER_48_141 VPWR VGND VPWR VGND sky130_ef_sc_hd__decap_12
XFILLER_0_181 VPWR VGND VPWR VGND sky130_ef_sc_hd__decap_12
X_1280_ _0077_ _0079_ _0576_ _0577_ _0579_ VGND VGND VPWR VPWR _0606_ sky130_fd_sc_hd__o221ai_4
XTAP_TAPCELL_ROW_46_364 VGND VPWR sky130_fd_sc_hd__tapvpwrvgnd_1
X_0995_ net128 net102 VGND VGND VPWR VPWR _0326_ sky130_fd_sc_hd__nand2_2
XFILLER_5_81 VPWR VGND VPWR VGND sky130_ef_sc_hd__decap_12
XPHY_EDGE_ROW_17_Left_70 VGND VGND VPWR VPWR sky130_fd_sc_hd__decap_3
XFILLER_24_57 VPWR VGND VPWR VGND sky130_ef_sc_hd__decap_12
XFILLER_40_23 VGND VGND VPWR VPWR sky130_fd_sc_hd__decap_4
XFILLER_10_247 VGND VGND VPWR VPWR sky130_fd_sc_hd__decap_4
Xhold281 net60 VGND VGND VPWR VPWR net416 sky130_fd_sc_hd__dlygate4sd3_1
Xhold270 net59 VGND VGND VPWR VPWR net405 sky130_fd_sc_hd__dlygate4sd3_1
XFILLER_45_188 VPWR VGND VPWR VGND sky130_ef_sc_hd__decap_12
XFILLER_45_166 VGND VGND VPWR VPWR sky130_fd_sc_hd__fill_2
XFILLER_1_39 VPWR VGND VPWR VGND sky130_ef_sc_hd__decap_12
X_0780_ _0145_ _0146_ _0147_ _0070_ VGND VGND VPWR VPWR _0149_ sky130_fd_sc_hd__a31o_1
X_1401_ clknet_3_6__leaf_clk _0027_ VGND VGND VPWR VPWR net55 sky130_fd_sc_hd__dfxtp_1
XFILLER_5_273 VGND VGND VPWR VPWR sky130_fd_sc_hd__decap_6
X_1332_ _0655_ _0656_ VGND VGND VPWR VPWR _0657_ sky130_fd_sc_hd__nand2_1
Xinput5 a_in[4] VGND VGND VPWR VPWR net5 sky130_fd_sc_hd__clkbuf_4
X_1194_ _0488_ _0489_ net178 _0475_ VGND VGND VPWR VPWR _0522_ sky130_fd_sc_hd__a2bb2o_1
X_1263_ _0546_ _0537_ _0539_ VGND VGND VPWR VPWR _0590_ sky130_fd_sc_hd__o21ai_1
XFILLER_51_158 VGND VGND VPWR VPWR sky130_fd_sc_hd__decap_8
XFILLER_51_125 VGND VGND VPWR VPWR sky130_fd_sc_hd__fill_1
XFILLER_36_177 VGND VGND VPWR VPWR sky130_fd_sc_hd__fill_2
XTAP_TAPCELL_ROW_34_301 VGND VPWR sky130_fd_sc_hd__tapvpwrvgnd_1
X_0978_ _0307_ _0308_ _0295_ VGND VGND VPWR VPWR _0310_ sky130_fd_sc_hd__o21bai_1
XFILLER_19_57 VGND VGND VPWR VPWR sky130_fd_sc_hd__decap_6
XFILLER_51_55 VGND VGND VPWR VPWR sky130_fd_sc_hd__fill_1
XFILLER_35_89 VPWR VGND VPWR VGND sky130_ef_sc_hd__decap_12
XPHY_EDGE_ROW_2_Left_55 VGND VGND VPWR VPWR sky130_fd_sc_hd__decap_3
XFILLER_30_309 VGND VGND VPWR VPWR sky130_fd_sc_hd__fill_2
XFILLER_2_265 VPWR VGND VPWR VGND sky130_ef_sc_hd__decap_12
XFILLER_2_221 VPWR VGND VPWR VGND sky130_ef_sc_hd__decap_12
XFILLER_33_169 VGND VGND VPWR VPWR sky130_fd_sc_hd__decap_4
X_0832_ _0187_ net42 product_reg\[14\] VGND VGND VPWR VPWR _0194_ sky130_fd_sc_hd__and3_1
X_0763_ _0119_ net361 _0125_ product_reg\[6\] net65 VGND VGND VPWR VPWR _0134_ sky130_fd_sc_hd__a32o_1
X_0901_ net373 net84 _0085_ _0236_ VGND VGND VPWR VPWR _0044_ sky130_fd_sc_hd__a31o_1
XFILLER_51_3 VPWR VGND VPWR VGND sky130_ef_sc_hd__decap_12
X_1315_ _0615_ _0638_ _0639_ VGND VGND VPWR VPWR _0640_ sky130_fd_sc_hd__and3_1
X_0694_ net129 VGND VGND VPWR VPWR _0074_ sky130_fd_sc_hd__clkinv_4
X_1246_ _0571_ net116 net102 _0526_ VGND VGND VPWR VPWR _0573_ sky130_fd_sc_hd__nand4_1
X_1177_ _0384_ _0502_ _0494_ _0499_ _0498_ VGND VGND VPWR VPWR _0506_ sky130_fd_sc_hd__o221a_1
XPHY_EDGE_ROW_44_Left_97 VGND VGND VPWR VPWR sky130_fd_sc_hd__decap_3
XFILLER_12_309 VGND VGND VPWR VPWR sky130_fd_sc_hd__fill_2
XFILLER_15_125 VGND VGND VPWR VPWR sky130_fd_sc_hd__decap_4
XFILLER_15_169 VGND VGND VPWR VPWR sky130_fd_sc_hd__fill_1
XFILLER_7_27 VPWR VGND VPWR VGND sky130_ef_sc_hd__decap_12
XFILLER_46_250 VGND VGND VPWR VPWR sky130_fd_sc_hd__fill_2
XFILLER_38_239 VPWR VGND VPWR VGND sky130_ef_sc_hd__decap_12
X_1100_ _0325_ _0336_ _0354_ _0421_ _0420_ VGND VGND VPWR VPWR _0430_ sky130_fd_sc_hd__o2111ai_4
X_1031_ net134 net117 VGND VGND VPWR VPWR _0362_ sky130_fd_sc_hd__nand2_1
X_0815_ product_reg\[14\] net42 VGND VGND VPWR VPWR _0179_ sky130_fd_sc_hd__or2_1
X_0746_ product_reg\[5\] net64 VGND VGND VPWR VPWR _0119_ sky130_fd_sc_hd__or2_1
XFILLER_37_272 VGND VGND VPWR VPWR sky130_fd_sc_hd__decap_4
X_1229_ _0387_ _0501_ _0500_ VGND VGND VPWR VPWR _0557_ sky130_fd_sc_hd__o21ai_4
XTAP_TAPCELL_ROW_7_154 VGND VPWR sky130_fd_sc_hd__tapvpwrvgnd_1
XFILLER_7_187 VPWR VGND VPWR VGND sky130_ef_sc_hd__decap_12
XFILLER_11_183 VGND VGND VPWR VPWR sky130_fd_sc_hd__fill_2
XFILLER_14_3 VPWR VGND VPWR VGND sky130_ef_sc_hd__decap_12
XFILLER_34_253 VGND VGND VPWR VPWR sky130_fd_sc_hd__fill_1
X_1014_ net110 net119 _0342_ _0343_ VGND VGND VPWR VPWR _0345_ sky130_fd_sc_hd__a22o_1
Xrebuffer229 net48 VGND VGND VPWR VPWR net364 sky130_fd_sc_hd__dlygate4sd1_1
X_0729_ product_reg\[3\] net62 VGND VGND VPWR VPWR _0104_ sky130_fd_sc_hd__and2_1
XTAP_TAPCELL_ROW_4_135 VGND VPWR sky130_fd_sc_hd__tapvpwrvgnd_1
XFILLER_43_23 VGND VGND VPWR VPWR sky130_fd_sc_hd__decap_3
XFILLER_40_245 VGND VGND VPWR VPWR sky130_fd_sc_hd__decap_4
XPHY_EDGE_ROW_31_Left_84 VGND VGND VPWR VPWR sky130_fd_sc_hd__decap_3
XTAP_TAPCELL_ROW_18_215 VGND VPWR sky130_fd_sc_hd__tapvpwrvgnd_1
XFILLER_31_223 VGND VGND VPWR VPWR sky130_fd_sc_hd__fill_1
XTAP_TAPCELL_ROW_49_384 VGND VPWR sky130_fd_sc_hd__tapvpwrvgnd_1
XFILLER_13_15 VPWR VGND VPWR VGND sky130_ef_sc_hd__decap_12
XFILLER_22_245 VGND VGND VPWR VPWR sky130_fd_sc_hd__decap_6
XFILLER_22_289 VGND VGND VPWR VPWR sky130_fd_sc_hd__decap_8
XFILLER_38_45 VGND VGND VPWR VPWR sky130_fd_sc_hd__fill_2
XFILLER_1_105 VGND VGND VPWR VPWR sky130_fd_sc_hd__decap_6
XFILLER_1_149 VPWR VGND VPWR VGND sky130_ef_sc_hd__decap_12
XFILLER_9_249 VPWR VGND VPWR VGND sky130_ef_sc_hd__decap_12
XTAP_TAPCELL_ROW_23_240 VGND VPWR sky130_fd_sc_hd__tapvpwrvgnd_1
XFILLER_48_153 VPWR VGND VPWR VGND sky130_ef_sc_hd__decap_12
XFILLER_0_193 VGND VGND VPWR VPWR sky130_fd_sc_hd__decap_3
XTAP_TAPCELL_ROW_46_365 VGND VPWR sky130_fd_sc_hd__tapvpwrvgnd_1
X_0994_ _0299_ _0300_ _0303_ VGND VGND VPWR VPWR _0325_ sky130_fd_sc_hd__o21a_1
XFILLER_5_93 VPWR VGND VPWR VGND sky130_ef_sc_hd__decap_12
XTAP_TAPCELL_ROW_20_221 VGND VPWR sky130_fd_sc_hd__tapvpwrvgnd_1
XFILLER_24_69 VGND VGND VPWR VPWR sky130_fd_sc_hd__fill_1
Xhold271 product_reg\[10\] VGND VGND VPWR VPWR net406 sky130_fd_sc_hd__dlygate4sd3_1
XFILLER_40_46 VGND VGND VPWR VPWR sky130_fd_sc_hd__fill_1
Xhold260 product_reg\[2\] VGND VGND VPWR VPWR net395 sky130_fd_sc_hd__dlygate4sd3_1
XFILLER_49_88 VGND VGND VPWR VPWR sky130_fd_sc_hd__decap_6
XFILLER_49_55 VGND VGND VPWR VPWR sky130_fd_sc_hd__fill_1
Xhold282 net55 VGND VGND VPWR VPWR net417 sky130_fd_sc_hd__dlygate4sd3_1
XFILLER_45_178 VGND VGND VPWR VPWR sky130_fd_sc_hd__decap_4
X_1400_ clknet_3_6__leaf_clk _0026_ VGND VGND VPWR VPWR net54 sky130_fd_sc_hd__dfxtp_1
X_1331_ _0654_ _0653_ _0648_ _0647_ VGND VGND VPWR VPWR _0656_ sky130_fd_sc_hd__o2bb2ai_1
Xinput6 a_in[5] VGND VGND VPWR VPWR net6 sky130_fd_sc_hd__buf_4
X_1262_ _0574_ _0575_ _0585_ _0586_ VGND VGND VPWR VPWR _0589_ sky130_fd_sc_hd__a22o_1
X_1193_ _0488_ _0489_ net137 _0475_ VGND VGND VPWR VPWR _0521_ sky130_fd_sc_hd__a2bb2oi_1
XTAP_TAPCELL_ROW_34_302 VGND VPWR sky130_fd_sc_hd__tapvpwrvgnd_1
XFILLER_10_27 VGND VGND VPWR VPWR sky130_fd_sc_hd__fill_1
X_0977_ _0266_ _0296_ _0304_ _0305_ VGND VGND VPWR VPWR _0309_ sky130_fd_sc_hd__nand4_4
XFILLER_35_57 VGND VGND VPWR VPWR sky130_fd_sc_hd__fill_2
Xclkbuf_3_3__f_clk clknet_0_clk VGND VGND VPWR VPWR clknet_3_3__leaf_clk sky130_fd_sc_hd__clkbuf_16
XPHY_EDGE_ROW_14_Right_14 VGND VGND VPWR VPWR sky130_fd_sc_hd__decap_3
XFILLER_2_277 VPWR VGND VPWR VGND sky130_ef_sc_hd__decap_12
XFILLER_2_233 VPWR VGND VPWR VGND sky130_ef_sc_hd__decap_12
XPHY_EDGE_ROW_23_Right_23 VGND VGND VPWR VPWR sky130_fd_sc_hd__decap_3
XPHY_EDGE_ROW_32_Right_32 VGND VGND VPWR VPWR sky130_fd_sc_hd__decap_3
X_0900_ _0000_ _0234_ _0235_ VGND VGND VPWR VPWR _0236_ sky130_fd_sc_hd__and3_1
X_0831_ product_reg\[15\] net43 _0192_ VGND VGND VPWR VPWR _0193_ sky130_fd_sc_hd__o21a_1
X_0762_ _0068_ _0071_ VGND VGND VPWR VPWR _0133_ sky130_fd_sc_hd__nor2_1
X_0693_ net104 VGND VGND VPWR VPWR _0073_ sky130_fd_sc_hd__inv_2
XFILLER_44_3 VPWR VGND VPWR VGND sky130_ef_sc_hd__decap_12
XPHY_EDGE_ROW_41_Right_41 VGND VGND VPWR VPWR sky130_fd_sc_hd__decap_3
X_1314_ _0636_ _0637_ _0610_ VGND VGND VPWR VPWR _0639_ sky130_fd_sc_hd__a21o_1
XPHY_EDGE_ROW_50_Right_50 VGND VGND VPWR VPWR sky130_fd_sc_hd__decap_3
XFILLER_49_281 VGND VGND VPWR VPWR sky130_fd_sc_hd__decap_8
X_1176_ net200 _0500_ _0501_ _0387_ VGND VGND VPWR VPWR _0505_ sky130_fd_sc_hd__o2bb2ai_2
XFILLER_2_83 VGND VGND VPWR VPWR sky130_fd_sc_hd__fill_1
X_1245_ _0076_ _0079_ _0524_ _0525_ _0529_ VGND VGND VPWR VPWR _0572_ sky130_fd_sc_hd__o221ai_4
XFILLER_32_192 VGND VGND VPWR VPWR sky130_fd_sc_hd__decap_4
XFILLER_7_39 VGND VGND VPWR VPWR sky130_fd_sc_hd__decap_8
XFILLER_16_7 VPWR VGND VPWR VGND sky130_ef_sc_hd__decap_12
X_1030_ _0338_ _0354_ _0357_ _0353_ VGND VGND VPWR VPWR _0361_ sky130_fd_sc_hd__o211ai_4
X_0814_ net79 net400 net88 _0178_ VGND VGND VPWR VPWR _0014_ sky130_fd_sc_hd__o211a_1
Xinput20 v_b_in VGND VGND VPWR VPWR net20 sky130_fd_sc_hd__clkbuf_2
X_0745_ product_reg\[5\] net64 VGND VGND VPWR VPWR _0118_ sky130_fd_sc_hd__nand2_1
X_1228_ _0485_ _0518_ _0553_ _0551_ VGND VGND VPWR VPWR _0556_ sky130_fd_sc_hd__o22ai_4
X_1159_ _0480_ _0483_ _0484_ VGND VGND VPWR VPWR _0488_ sky130_fd_sc_hd__and3_1
XFILLER_28_284 VGND VGND VPWR VPWR sky130_fd_sc_hd__decap_6
XFILLER_7_199 VPWR VGND VPWR VGND sky130_ef_sc_hd__decap_12
XFILLER_7_166 VGND VGND VPWR VPWR sky130_fd_sc_hd__fill_2
X_1013_ net110 net119 _0342_ _0343_ VGND VGND VPWR VPWR _0344_ sky130_fd_sc_hd__a22oi_4
Xrebuffer208 _0343_ VGND VGND VPWR VPWR net343 sky130_fd_sc_hd__buf_1
X_0728_ _0098_ _0096_ _0089_ _0095_ VGND VGND VPWR VPWR _0103_ sky130_fd_sc_hd__o31ai_4
XPHY_EDGE_ROW_4_Right_4 VGND VGND VPWR VPWR sky130_fd_sc_hd__decap_3
XTAP_TAPCELL_ROW_4_136 VGND VPWR sky130_fd_sc_hd__tapvpwrvgnd_1
XFILLER_43_57 VGND VGND VPWR VPWR sky130_fd_sc_hd__decap_4
XFILLER_43_46 VGND VGND VPWR VPWR sky130_fd_sc_hd__decap_8
XFILLER_40_279 VPWR VGND VPWR VGND sky130_ef_sc_hd__decap_12
XFILLER_40_213 VGND VGND VPWR VPWR sky130_fd_sc_hd__fill_1
XFILLER_4_29 VPWR VGND VPWR VGND sky130_ef_sc_hd__decap_12
XTAP_TAPCELL_ROW_49_385 VGND VPWR sky130_fd_sc_hd__tapvpwrvgnd_1
XTAP_TAPCELL_ROW_1_117 VGND VPWR sky130_fd_sc_hd__tapvpwrvgnd_1
XFILLER_13_27 VPWR VGND VPWR VGND sky130_ef_sc_hd__decap_12
XFILLER_38_68 VPWR VGND VPWR VGND sky130_ef_sc_hd__decap_12
XFILLER_38_24 VGND VGND VPWR VPWR sky130_fd_sc_hd__decap_4
XTAP_TAPCELL_ROW_23_241 VGND VPWR sky130_fd_sc_hd__tapvpwrvgnd_1
XFILLER_48_165 VPWR VGND VPWR VGND sky130_ef_sc_hd__decap_12
XTAP_TAPCELL_ROW_46_366 VGND VPWR sky130_fd_sc_hd__tapvpwrvgnd_1
X_0993_ _0299_ _0300_ VGND VGND VPWR VPWR _0324_ sky130_fd_sc_hd__nor2_1
XFILLER_6_209 VPWR VGND VPWR VGND sky130_ef_sc_hd__decap_12
XTAP_TAPCELL_ROW_20_222 VGND VPWR sky130_fd_sc_hd__tapvpwrvgnd_1
XFILLER_24_26 VGND VGND VPWR VPWR sky130_fd_sc_hd__fill_2
Xhold261 net44 VGND VGND VPWR VPWR net396 sky130_fd_sc_hd__dlygate4sd3_1
Xhold272 net63 VGND VGND VPWR VPWR net407 sky130_fd_sc_hd__dlygate4sd3_1
XFILLER_40_69 VGND VGND VPWR VPWR sky130_fd_sc_hd__decap_3
XFILLER_40_58 VGND VGND VPWR VPWR sky130_fd_sc_hd__decap_3
X_1330_ _0653_ _0654_ _0650_ VGND VGND VPWR VPWR _0655_ sky130_fd_sc_hd__nand3_2
X_1261_ _0574_ _0575_ _0585_ _0586_ VGND VGND VPWR VPWR _0588_ sky130_fd_sc_hd__nand4_4
XFILLER_30_91 VGND VGND VPWR VPWR sky130_fd_sc_hd__fill_1
XTAP_TAPCELL_ROW_34_303 VGND VPWR sky130_fd_sc_hd__tapvpwrvgnd_1
Xinput7 a_in[6] VGND VGND VPWR VPWR net7 sky130_fd_sc_hd__clkbuf_1
X_1192_ _0519_ VGND VGND VPWR VPWR _0520_ sky130_fd_sc_hd__inv_2
X_0976_ _0304_ _0297_ _0305_ VGND VGND VPWR VPWR _0308_ sky130_fd_sc_hd__and3_4
XFILLER_51_57 VGND VGND VPWR VPWR sky130_fd_sc_hd__decap_3
XFILLER_4_3 VPWR VGND VPWR VGND sky130_ef_sc_hd__decap_12
XFILLER_2_289 VPWR VGND VPWR VGND sky130_ef_sc_hd__decap_12
XFILLER_2_245 VGND VGND VPWR VPWR sky130_fd_sc_hd__decap_6
X_0830_ product_reg\[15\] net43 net42 product_reg\[14\] VGND VGND VPWR VPWR _0192_
+ sky130_fd_sc_hd__a211o_1
X_0761_ product_reg\[7\] net66 VGND VGND VPWR VPWR _0132_ sky130_fd_sc_hd__or2_1
X_0692_ net64 VGND VGND VPWR VPWR _0072_ sky130_fd_sc_hd__inv_2
X_1244_ _0076_ _0078_ _0529_ VGND VGND VPWR VPWR _0571_ sky130_fd_sc_hd__o21ai_1
X_1313_ _0078_ _0080_ _0636_ _0637_ VGND VGND VPWR VPWR _0638_ sky130_fd_sc_hd__o211ai_2
X_1175_ _0500_ _0498_ _0503_ VGND VGND VPWR VPWR _0504_ sky130_fd_sc_hd__a21oi_4
XFILLER_21_49 VGND VGND VPWR VPWR sky130_fd_sc_hd__fill_1
X_0959_ net108 net127 net112 net193 VGND VGND VPWR VPWR _0291_ sky130_fd_sc_hd__a22oi_4
XFILLER_23_193 VGND VGND VPWR VPWR sky130_fd_sc_hd__decap_3
XFILLER_46_296 VGND VGND VPWR VPWR sky130_fd_sc_hd__decap_8
X_0813_ _0177_ net79 _0176_ VGND VGND VPWR VPWR _0178_ sky130_fd_sc_hd__nand3b_4
Xinput10 b_in[1] VGND VGND VPWR VPWR net10 sky130_fd_sc_hd__buf_1
XTAP_TAPCELL_ROW_16_199 VGND VPWR sky130_fd_sc_hd__tapvpwrvgnd_1
X_0744_ _0113_ _0110_ _0111_ VGND VGND VPWR VPWR _0117_ sky130_fd_sc_hd__o21a_1
X_1227_ _0552_ _0554_ VGND VGND VPWR VPWR _0555_ sky130_fd_sc_hd__nand2_4
X_1158_ _0483_ _0484_ net113 net115 VGND VGND VPWR VPWR _0487_ sky130_fd_sc_hd__and4_2
XFILLER_52_222 VGND VGND VPWR VPWR sky130_fd_sc_hd__fill_2
X_1089_ _0414_ _0416_ VGND VGND VPWR VPWR _0419_ sky130_fd_sc_hd__nand2_1
XFILLER_16_27 VGND VGND VPWR VPWR sky130_fd_sc_hd__fill_1
XFILLER_4_307 VGND VGND VPWR VPWR sky130_fd_sc_hd__fill_1
XFILLER_7_134 VPWR VGND VPWR VGND sky130_ef_sc_hd__decap_12
XFILLER_7_101 VGND VGND VPWR VPWR sky130_fd_sc_hd__fill_1
X_1012_ net123 net107 net126 net105 VGND VGND VPWR VPWR _0343_ sky130_fd_sc_hd__nand4_4
XFILLER_34_266 VGND VGND VPWR VPWR sky130_fd_sc_hd__fill_2
X_0727_ net78 net405 net86 _0102_ VGND VGND VPWR VPWR _0003_ sky130_fd_sc_hd__o211a_1
XTAP_TAPCELL_ROW_12_180 VGND VPWR sky130_fd_sc_hd__tapvpwrvgnd_1
Xrebuffer209 _0344_ VGND VGND VPWR VPWR net344 sky130_fd_sc_hd__clkbuf_2
XTAP_TAPCELL_ROW_4_137 VGND VPWR sky130_fd_sc_hd__tapvpwrvgnd_1
XFILLER_27_48 VGND VGND VPWR VPWR sky130_fd_sc_hd__fill_1
XFILLER_3_181 VPWR VGND VPWR VGND sky130_ef_sc_hd__decap_12
XTAP_TAPCELL_ROW_1_118 VGND VPWR sky130_fd_sc_hd__tapvpwrvgnd_1
XFILLER_13_39 VGND VGND VPWR VPWR sky130_fd_sc_hd__fill_1
XFILLER_38_58 VGND VGND VPWR VPWR sky130_fd_sc_hd__decap_3
XTAP_TAPCELL_ROW_23_242 VGND VPWR sky130_fd_sc_hd__tapvpwrvgnd_1
XFILLER_28_80 VGND VGND VPWR VPWR sky130_fd_sc_hd__decap_4
XFILLER_28_91 VGND VGND VPWR VPWR sky130_fd_sc_hd__decap_6
XTAP_TAPCELL_ROW_46_367 VGND VPWR sky130_fd_sc_hd__tapvpwrvgnd_1
X_0992_ _0316_ _0275_ _0314_ VGND VGND VPWR VPWR _0323_ sky130_fd_sc_hd__a21o_1
XFILLER_8_251 VGND VGND VPWR VPWR sky130_fd_sc_hd__fill_1
XFILLER_5_51 VGND VGND VPWR VPWR sky130_fd_sc_hd__decap_4
XFILLER_39_111 VGND VGND VPWR VPWR sky130_fd_sc_hd__fill_1
XFILLER_42_309 VGND VGND VPWR VPWR sky130_fd_sc_hd__fill_2
XTAP_TAPCELL_ROW_20_223 VGND VPWR sky130_fd_sc_hd__tapvpwrvgnd_1
Xhold273 net40 VGND VGND VPWR VPWR net408 sky130_fd_sc_hd__dlygate4sd3_1
XFILLER_49_57 VPWR VGND VPWR VGND sky130_ef_sc_hd__decap_12
Xhold262 product_reg\[14\] VGND VGND VPWR VPWR net397 sky130_fd_sc_hd__dlygate4sd3_1
XFILLER_45_169 VGND VGND VPWR VPWR sky130_fd_sc_hd__decap_3
XFILLER_18_306 VGND VGND VPWR VPWR sky130_fd_sc_hd__fill_2
XTAP_TAPCELL_ROW_43_348 VGND VPWR sky130_fd_sc_hd__tapvpwrvgnd_1
XTAP_TAPCELL_ROW_51_392 VGND VPWR sky130_fd_sc_hd__tapvpwrvgnd_1
X_1191_ _0480_ _0485_ _0483_ VGND VGND VPWR VPWR _0519_ sky130_fd_sc_hd__o21ai_1
X_1260_ _0574_ _0575_ _0585_ VGND VGND VPWR VPWR _0587_ sky130_fd_sc_hd__nand3_1
Xinput8 a_in[7] VGND VGND VPWR VPWR net8 sky130_fd_sc_hd__clkbuf_1
XFILLER_24_309 VGND VGND VPWR VPWR sky130_fd_sc_hd__fill_2
X_0975_ _0266_ _0296_ _0305_ _0304_ VGND VGND VPWR VPWR _0307_ sky130_fd_sc_hd__a22oi_4
X_1389_ clknet_3_3__leaf_clk _0015_ VGND VGND VPWR VPWR net42 sky130_fd_sc_hd__dfxtp_1
XFILLER_35_15 VGND VGND VPWR VPWR sky130_fd_sc_hd__decap_4
XFILLER_33_139 VGND VGND VPWR VPWR sky130_fd_sc_hd__decap_4
XFILLER_41_161 VGND VGND VPWR VPWR sky130_fd_sc_hd__decap_6
X_0760_ product_reg\[7\] net66 VGND VGND VPWR VPWR _0131_ sky130_fd_sc_hd__nor2_1
X_0691_ net66 VGND VGND VPWR VPWR _0071_ sky130_fd_sc_hd__inv_2
X_1243_ _0520_ _0553_ _0552_ VGND VGND VPWR VPWR _0570_ sky130_fd_sc_hd__o21ai_1
X_1312_ _0077_ net89 _0611_ _0079_ _0634_ VGND VGND VPWR VPWR _0637_ sky130_fd_sc_hd__o221ai_4
XFILLER_2_85 VPWR VGND VPWR VGND sky130_ef_sc_hd__decap_12
XFILLER_2_41 VPWR VGND VPWR VGND sky130_ef_sc_hd__decap_12
X_1174_ net134 net115 _0386_ _0384_ VGND VGND VPWR VPWR _0503_ sky130_fd_sc_hd__a31o_1
X_0889_ net108 net84 VGND VGND VPWR VPWR _0037_ sky130_fd_sc_hd__and2_1
X_0958_ net108 net110 net127 net123 VGND VGND VPWR VPWR _0290_ sky130_fd_sc_hd__nand4_4
XPHY_EDGE_ROW_6_Left_59 VGND VGND VPWR VPWR sky130_fd_sc_hd__decap_3
XFILLER_7_305 VGND VGND VPWR VPWR sky130_fd_sc_hd__decap_6
XFILLER_38_209 VPWR VGND VPWR VGND sky130_ef_sc_hd__decap_12
XFILLER_14_172 VGND VGND VPWR VPWR sky130_fd_sc_hd__fill_1
X_0812_ _0170_ _0164_ _0173_ _0175_ VGND VGND VPWR VPWR _0177_ sky130_fd_sc_hd__and4_1
X_0743_ net77 net407 net86 _0116_ VGND VGND VPWR VPWR _0005_ sky130_fd_sc_hd__o211a_1
Xinput11 b_in[2] VGND VGND VPWR VPWR net11 sky130_fd_sc_hd__clkbuf_1
XFILLER_37_286 VGND VGND VPWR VPWR sky130_fd_sc_hd__fill_2
X_1157_ net113 net115 _0483_ _0484_ VGND VGND VPWR VPWR _0486_ sky130_fd_sc_hd__a22oi_4
X_1226_ net147 _0522_ _0547_ _0548_ _0520_ VGND VGND VPWR VPWR _0554_ sky130_fd_sc_hd__a41oi_2
XFILLER_32_16 VGND VGND VPWR VPWR sky130_fd_sc_hd__fill_1
X_1088_ _0410_ _0412_ net107 net119 VGND VGND VPWR VPWR _0418_ sky130_fd_sc_hd__and4_1
XFILLER_20_186 VGND VGND VPWR VPWR sky130_fd_sc_hd__fill_1
XFILLER_43_245 VPWR VGND VPWR VGND sky130_ef_sc_hd__decap_12
XFILLER_43_223 VGND VGND VPWR VPWR sky130_fd_sc_hd__fill_1
XFILLER_28_253 VGND VGND VPWR VPWR sky130_fd_sc_hd__fill_2
XFILLER_28_264 VPWR VGND VPWR VGND sky130_ef_sc_hd__decap_12
XFILLER_7_146 VPWR VGND VPWR VGND sky130_ef_sc_hd__decap_12
XFILLER_7_113 VGND VGND VPWR VPWR sky130_fd_sc_hd__decap_6
X_1011_ net104 net126 net123 net107 VGND VGND VPWR VPWR _0342_ sky130_fd_sc_hd__a22o_2
X_0726_ _0100_ _0101_ net78 VGND VGND VPWR VPWR _0102_ sky130_fd_sc_hd__o21ai_1
XFILLER_8_62 VGND VGND VPWR VPWR sky130_fd_sc_hd__fill_1
XTAP_TAPCELL_ROW_12_181 VGND VPWR sky130_fd_sc_hd__tapvpwrvgnd_1
XTAP_TAPCELL_ROW_4_138 VGND VPWR sky130_fd_sc_hd__tapvpwrvgnd_1
XFILLER_43_15 VGND VGND VPWR VPWR sky130_fd_sc_hd__decap_8
X_1209_ _0534_ _0535_ _0536_ _0468_ VGND VGND VPWR VPWR _0537_ sky130_fd_sc_hd__a22oi_4
XFILLER_25_223 VGND VGND VPWR VPWR sky130_fd_sc_hd__fill_1
XFILLER_16_201 VGND VGND VPWR VPWR sky130_fd_sc_hd__fill_1
XPHY_EDGE_ROW_9_Left_62 VGND VGND VPWR VPWR sky130_fd_sc_hd__decap_3
XFILLER_33_81 VPWR VGND VPWR VGND sky130_ef_sc_hd__decap_12
XFILLER_3_193 VPWR VGND VPWR VGND sky130_ef_sc_hd__decap_12
XFILLER_12_3 VPWR VGND VPWR VGND sky130_ef_sc_hd__decap_12
XTAP_TAPCELL_ROW_1_119 VGND VPWR sky130_fd_sc_hd__tapvpwrvgnd_1
XTAP_TAPCELL_ROW_32_287 VGND VPWR sky130_fd_sc_hd__tapvpwrvgnd_1
X_0709_ product_reg\[0\] net78 net403 VGND VGND VPWR VPWR _0087_ sky130_fd_sc_hd__a21oi_1
XFILLER_38_37 VGND VGND VPWR VPWR sky130_fd_sc_hd__decap_8
XPHY_EDGE_ROW_35_Left_88 VGND VGND VPWR VPWR sky130_fd_sc_hd__decap_3
XFILLER_13_237 VGND VGND VPWR VPWR sky130_fd_sc_hd__fill_2
XFILLER_0_141 VPWR VGND VPWR VGND sky130_ef_sc_hd__decap_12
XTAP_TAPCELL_ROW_46_368 VGND VPWR sky130_fd_sc_hd__tapvpwrvgnd_1
XFILLER_28_70 VGND VGND VPWR VPWR sky130_fd_sc_hd__decap_6
X_0991_ _0320_ _0322_ product_reg\[5\] _0232_ VGND VGND VPWR VPWR _0048_ sky130_fd_sc_hd__a2bb2o_2
XFILLER_39_178 VGND VGND VPWR VPWR sky130_fd_sc_hd__fill_2
XFILLER_40_27 VGND VGND VPWR VPWR sky130_fd_sc_hd__fill_1
XFILLER_10_218 VGND VGND VPWR VPWR sky130_fd_sc_hd__decap_6
XTAP_TAPCELL_ROW_20_224 VGND VPWR sky130_fd_sc_hd__tapvpwrvgnd_1
XFILLER_49_69 VGND VGND VPWR VPWR sky130_fd_sc_hd__decap_4
Xhold263 net62 VGND VGND VPWR VPWR net398 sky130_fd_sc_hd__dlygate4sd3_1
Xhold274 net67 VGND VGND VPWR VPWR net409 sky130_fd_sc_hd__dlygate4sd3_1
XTAP_TAPCELL_ROW_51_393 VGND VPWR sky130_fd_sc_hd__tapvpwrvgnd_1
XTAP_TAPCELL_ROW_43_349 VGND VPWR sky130_fd_sc_hd__tapvpwrvgnd_1
XFILLER_41_310 VGND VGND VPWR VPWR sky130_fd_sc_hd__fill_1
XFILLER_30_71 VPWR VGND VPWR VGND sky130_ef_sc_hd__decap_12
XFILLER_39_91 VGND VGND VPWR VPWR sky130_fd_sc_hd__decap_4
XFILLER_39_80 VGND VGND VPWR VPWR sky130_fd_sc_hd__fill_2
X_1190_ _0480_ _0483_ VGND VGND VPWR VPWR _0518_ sky130_fd_sc_hd__and2_1
Xinput9 b_in[0] VGND VGND VPWR VPWR net9 sky130_fd_sc_hd__clkbuf_2
XFILLER_36_137 VGND VGND VPWR VPWR sky130_fd_sc_hd__decap_3
XFILLER_10_19 VGND VGND VPWR VPWR sky130_fd_sc_hd__decap_8
X_0974_ _0305_ _0304_ VGND VGND VPWR VPWR _0306_ sky130_fd_sc_hd__nand2_2
X_1388_ clknet_3_2__leaf_clk _0014_ VGND VGND VPWR VPWR net41 sky130_fd_sc_hd__dfxtp_1
XFILLER_51_15 VPWR VGND VPWR VGND sky130_ef_sc_hd__decap_12
XFILLER_50_184 VGND VGND VPWR VPWR sky130_fd_sc_hd__decap_4
XFILLER_18_137 VGND VGND VPWR VPWR sky130_fd_sc_hd__decap_3
X_0690_ net77 VGND VGND VPWR VPWR _0070_ sky130_fd_sc_hd__inv_2
XFILLER_41_173 VGND VGND VPWR VPWR sky130_fd_sc_hd__decap_6
XFILLER_41_81 VPWR VGND VPWR VGND sky130_ef_sc_hd__decap_12
XPHY_EDGE_ROW_38_Left_91 VGND VGND VPWR VPWR sky130_fd_sc_hd__decap_3
XPHY_EDGE_ROW_22_Left_75 VGND VGND VPWR VPWR sky130_fd_sc_hd__decap_3
X_1311_ _0635_ net114 net153 VGND VGND VPWR VPWR _0636_ sky130_fd_sc_hd__nand3_1
X_1242_ _0561_ _0511_ _0558_ VGND VGND VPWR VPWR _0569_ sky130_fd_sc_hd__a21o_1
XFILLER_2_97 VPWR VGND VPWR VGND sky130_ef_sc_hd__decap_12
XFILLER_2_53 VPWR VGND VPWR VGND sky130_ef_sc_hd__decap_12
XPHY_EDGE_ROW_10_Right_10 VGND VGND VPWR VPWR sky130_fd_sc_hd__decap_3
X_1173_ _0386_ net115 net134 VGND VGND VPWR VPWR _0502_ sky130_fd_sc_hd__and3_1
X_0957_ net123 net112 net127 net108 VGND VGND VPWR VPWR _0289_ sky130_fd_sc_hd__and4_1
X_0888_ net111 net84 VGND VGND VPWR VPWR _0036_ sky130_fd_sc_hd__and2_1
XFILLER_46_15 VPWR VGND VPWR VGND sky130_ef_sc_hd__decap_12
XFILLER_15_129 VGND VGND VPWR VPWR sky130_fd_sc_hd__fill_1
XFILLER_36_81 VGND VGND VPWR VPWR sky130_fd_sc_hd__decap_3
X_0811_ _0164_ _0170_ _0173_ _0175_ VGND VGND VPWR VPWR _0176_ sky130_fd_sc_hd__a22o_1
X_0742_ _0114_ _0115_ _0070_ VGND VGND VPWR VPWR _0116_ sky130_fd_sc_hd__a21o_1
Xinput12 b_in[3] VGND VGND VPWR VPWR net12 sky130_fd_sc_hd__clkbuf_2
XFILLER_37_276 VGND VGND VPWR VPWR sky130_fd_sc_hd__fill_1
XFILLER_16_29 VGND VGND VPWR VPWR sky130_fd_sc_hd__decap_3
X_1087_ net107 net119 _0409_ _0411_ VGND VGND VPWR VPWR _0417_ sky130_fd_sc_hd__o2bb2a_2
X_1225_ _0492_ net144 _0549_ _0550_ VGND VGND VPWR VPWR _0553_ sky130_fd_sc_hd__a22oi_4
X_1156_ _0484_ VGND VGND VPWR VPWR _0485_ sky130_fd_sc_hd__inv_2
XFILLER_52_279 VGND VGND VPWR VPWR sky130_fd_sc_hd__fill_1
XFILLER_4_309 VGND VGND VPWR VPWR sky130_fd_sc_hd__fill_2
XFILLER_43_257 VGND VGND VPWR VPWR sky130_fd_sc_hd__decap_3
XFILLER_7_158 VGND VGND VPWR VPWR sky130_fd_sc_hd__decap_8
XFILLER_11_165 VGND VGND VPWR VPWR sky130_fd_sc_hd__decap_3
XFILLER_19_210 VGND VGND VPWR VPWR sky130_fd_sc_hd__fill_1
X_1010_ net105 net126 net123 net107 VGND VGND VPWR VPWR _0341_ sky130_fd_sc_hd__a22oi_4
XTAP_TAPCELL_ROW_29_271 VGND VPWR sky130_fd_sc_hd__tapvpwrvgnd_1
XFILLER_8_85 VGND VGND VPWR VPWR sky130_fd_sc_hd__fill_1
XFILLER_8_41 VGND VGND VPWR VPWR sky130_fd_sc_hd__decap_4
X_0725_ _0090_ _0095_ _0097_ _0099_ VGND VGND VPWR VPWR _0101_ sky130_fd_sc_hd__and4_1
XTAP_TAPCELL_ROW_12_182 VGND VPWR sky130_fd_sc_hd__tapvpwrvgnd_1
X_1208_ net167 _0458_ net201 VGND VGND VPWR VPWR _0536_ sky130_fd_sc_hd__o21ai_4
XFILLER_33_290 VGND VGND VPWR VPWR sky130_fd_sc_hd__fill_2
X_1139_ _0395_ net140 _0459_ _0462_ _0399_ VGND VGND VPWR VPWR _0468_ sky130_fd_sc_hd__o221ai_4
XFILLER_4_139 VGND VGND VPWR VPWR sky130_fd_sc_hd__fill_1
XFILLER_16_257 VPWR VGND VPWR VGND sky130_ef_sc_hd__decap_12
XFILLER_3_161 VGND VGND VPWR VPWR sky130_fd_sc_hd__decap_6
XPHY_EDGE_ROW_8_Right_8 VGND VGND VPWR VPWR sky130_fd_sc_hd__decap_3
XTAP_TAPCELL_ROW_32_288 VGND VPWR sky130_fd_sc_hd__tapvpwrvgnd_1
XFILLER_30_282 VGND VGND VPWR VPWR sky130_fd_sc_hd__fill_2
XPHY_EDGE_ROW_39_Right_39 VGND VGND VPWR VPWR sky130_fd_sc_hd__decap_3
X_0708_ _0086_ VGND VGND VPWR VPWR _0000_ sky130_fd_sc_hd__inv_2
XPHY_EDGE_ROW_48_Right_48 VGND VGND VPWR VPWR sky130_fd_sc_hd__decap_3
XFILLER_48_113 VGND VGND VPWR VPWR sky130_fd_sc_hd__decap_8
XFILLER_0_153 VPWR VGND VPWR VGND sky130_ef_sc_hd__decap_12
XFILLER_0_197 VPWR VGND VPWR VGND sky130_ef_sc_hd__decap_12
XTAP_TAPCELL_ROW_46_369 VGND VPWR sky130_fd_sc_hd__tapvpwrvgnd_1
XFILLER_8_253 VPWR VGND VPWR VGND sky130_ef_sc_hd__decap_12
X_0990_ _0281_ _0319_ _0284_ _0086_ VGND VGND VPWR VPWR _0322_ sky130_fd_sc_hd__a31o_1
Xhold253 product_reg\[8\] VGND VGND VPWR VPWR net388 sky130_fd_sc_hd__dlygate4sd3_1
XTAP_TAPCELL_ROW_20_225 VGND VPWR sky130_fd_sc_hd__tapvpwrvgnd_1
Xhold264 net61 VGND VGND VPWR VPWR net399 sky130_fd_sc_hd__dlygate4sd3_1
Xhold275 net42 VGND VGND VPWR VPWR net410 sky130_fd_sc_hd__dlygate4sd3_1
XFILLER_49_15 VPWR VGND VPWR VGND sky130_ef_sc_hd__decap_12
XFILLER_45_127 VGND VGND VPWR VPWR sky130_fd_sc_hd__decap_3
XTAP_TAPCELL_ROW_51_394 VGND VPWR sky130_fd_sc_hd__tapvpwrvgnd_1
XFILLER_5_223 VGND VGND VPWR VPWR sky130_fd_sc_hd__fill_1
XFILLER_30_83 VGND VGND VPWR VPWR sky130_fd_sc_hd__fill_1
X_0973_ _0301_ _0303_ net105 net129 VGND VGND VPWR VPWR _0305_ sky130_fd_sc_hd__nand4_4
X_1387_ clknet_3_2__leaf_clk _0013_ VGND VGND VPWR VPWR net40 sky130_fd_sc_hd__dfxtp_1
XFILLER_42_108 VPWR VGND VPWR VGND sky130_ef_sc_hd__decap_12
XFILLER_27_149 VGND VGND VPWR VPWR sky130_fd_sc_hd__fill_2
XFILLER_51_27 VPWR VGND VPWR VGND sky130_ef_sc_hd__decap_12
XFILLER_18_127 VGND VGND VPWR VPWR sky130_fd_sc_hd__decap_3
XFILLER_41_141 VGND VGND VPWR VPWR sky130_fd_sc_hd__fill_1
XFILLER_33_108 VGND VGND VPWR VPWR sky130_fd_sc_hd__decap_4
XFILLER_41_93 VGND VGND VPWR VPWR sky130_fd_sc_hd__fill_2
X_1241_ _0504_ _0510_ _0561_ VGND VGND VPWR VPWR _0568_ sky130_fd_sc_hd__o21ai_1
XFILLER_1_281 VPWR VGND VPWR VGND sky130_ef_sc_hd__decap_12
X_1310_ _0079_ _0611_ _0634_ VGND VGND VPWR VPWR _0635_ sky130_fd_sc_hd__o21ai_1
XFILLER_2_65 VPWR VGND VPWR VGND sky130_ef_sc_hd__decap_12
X_1172_ _0075_ _0081_ _0385_ VGND VGND VPWR VPWR _0501_ sky130_fd_sc_hd__o21a_1
XFILLER_32_141 VGND VGND VPWR VPWR sky130_fd_sc_hd__fill_1
X_0956_ _0263_ _0268_ _0269_ _0273_ _0278_ VGND VGND VPWR VPWR _0288_ sky130_fd_sc_hd__a32o_2
X_0887_ _0075_ net82 VGND VGND VPWR VPWR _0035_ sky130_fd_sc_hd__nor2_1
X_1439_ clknet_3_3__leaf_clk _0065_ VGND VGND VPWR VPWR net35 sky130_fd_sc_hd__dfxtp_1
XFILLER_46_49 VGND VGND VPWR VPWR sky130_fd_sc_hd__decap_3
XFILLER_46_27 VGND VGND VPWR VPWR sky130_fd_sc_hd__fill_1
XFILLER_23_185 VGND VGND VPWR VPWR sky130_fd_sc_hd__decap_8
XFILLER_2_3 VPWR VGND VPWR VGND sky130_ef_sc_hd__decap_12
XFILLER_46_277 VGND VGND VPWR VPWR sky130_fd_sc_hd__fill_2
XFILLER_46_233 VGND VGND VPWR VPWR sky130_fd_sc_hd__fill_2
X_0810_ product_reg\[13\] net41 VGND VGND VPWR VPWR _0175_ sky130_fd_sc_hd__nand2_1
Xinput13 b_in[4] VGND VGND VPWR VPWR net13 sky130_fd_sc_hd__clkbuf_1
X_0741_ _0113_ _0110_ VGND VGND VPWR VPWR _0115_ sky130_fd_sc_hd__or2_1
XFILLER_35_3 VGND VGND VPWR VPWR sky130_fd_sc_hd__decap_3
X_1224_ _0478_ _0521_ _0547_ _0548_ VGND VGND VPWR VPWR _0552_ sky130_fd_sc_hd__a2bb2o_1
XFILLER_16_19 VGND VGND VPWR VPWR sky130_fd_sc_hd__decap_8
X_1086_ _0409_ _0411_ _0408_ VGND VGND VPWR VPWR _0416_ sky130_fd_sc_hd__o21bai_1
X_1155_ _0408_ _0409_ _0412_ _0481_ VGND VGND VPWR VPWR _0484_ sky130_fd_sc_hd__o211ai_4
X_0939_ _0263_ _0268_ _0269_ VGND VGND VPWR VPWR _0272_ sky130_fd_sc_hd__nand3_1
XTAP_TAPCELL_ROW_29_272 VGND VPWR sky130_fd_sc_hd__tapvpwrvgnd_1
X_0724_ _0095_ _0097_ _0098_ _0089_ VGND VGND VPWR VPWR _0100_ sky130_fd_sc_hd__o2bb2a_1
X_1207_ _0532_ _0533_ _0523_ VGND VGND VPWR VPWR _0535_ sky130_fd_sc_hd__nand3_4
XFILLER_25_203 VGND VGND VPWR VPWR sky130_fd_sc_hd__fill_2
X_1069_ net92 net130 net95 net93 VGND VGND VPWR VPWR _0399_ sky130_fd_sc_hd__nand4_4
X_1138_ _0460_ _0463_ _0465_ _0397_ VGND VGND VPWR VPWR _0467_ sky130_fd_sc_hd__a22oi_4
XFILLER_16_225 VGND VGND VPWR VPWR sky130_fd_sc_hd__fill_1
XFILLER_16_269 VPWR VGND VPWR VGND sky130_ef_sc_hd__decap_12
XFILLER_24_291 VGND VGND VPWR VPWR sky130_fd_sc_hd__fill_1
X_0707_ net17 net18 _0085_ VGND VGND VPWR VPWR _0086_ sky130_fd_sc_hd__or3_4
XTAP_TAPCELL_ROW_32_289 VGND VPWR sky130_fd_sc_hd__tapvpwrvgnd_1
XTAP_TAPCELL_ROW_0_110 VGND VPWR sky130_fd_sc_hd__tapvpwrvgnd_1
XFILLER_36_309 VGND VGND VPWR VPWR sky130_fd_sc_hd__fill_2
XFILLER_0_165 VGND VGND VPWR VPWR sky130_fd_sc_hd__decap_3
XFILLER_28_50 VGND VGND VPWR VPWR sky130_fd_sc_hd__decap_3
XFILLER_8_265 VPWR VGND VPWR VGND sky130_ef_sc_hd__decap_12
XFILLER_8_221 VPWR VGND VPWR VGND sky130_ef_sc_hd__decap_12
XTAP_TAPCELL_ROW_37_315 VGND VPWR sky130_fd_sc_hd__tapvpwrvgnd_1
XTAP_TAPCELL_ROW_20_226 VGND VPWR sky130_fd_sc_hd__tapvpwrvgnd_1
Xhold276 net54 VGND VGND VPWR VPWR net411 sky130_fd_sc_hd__dlygate4sd3_1
Xhold265 net41 VGND VGND VPWR VPWR net400 sky130_fd_sc_hd__dlygate4sd3_1
XFILLER_49_27 VPWR VGND VPWR VGND sky130_ef_sc_hd__decap_12
Xhold254 product_reg\[6\] VGND VGND VPWR VPWR net389 sky130_fd_sc_hd__dlygate4sd3_1
XFILLER_18_309 VGND VGND VPWR VPWR sky130_fd_sc_hd__fill_2
XTAP_TAPCELL_ROW_51_395 VGND VPWR sky130_fd_sc_hd__tapvpwrvgnd_1
XFILLER_14_52 VGND VGND VPWR VPWR sky130_fd_sc_hd__fill_1
XFILLER_5_279 VGND VGND VPWR VPWR sky130_fd_sc_hd__fill_1
XFILLER_44_161 VPWR VGND VPWR VGND sky130_ef_sc_hd__decap_12
X_0972_ _0073_ _0074_ _0300_ _0302_ VGND VGND VPWR VPWR _0304_ sky130_fd_sc_hd__o22ai_4
X_1386_ clknet_3_2__leaf_clk _0012_ VGND VGND VPWR VPWR net39 sky130_fd_sc_hd__dfxtp_1
XFILLER_51_39 VPWR VGND VPWR VGND sky130_ef_sc_hd__decap_12
XFILLER_14_301 VGND VGND VPWR VPWR sky130_fd_sc_hd__decap_6
XFILLER_26_161 VPWR VGND VPWR VGND sky130_ef_sc_hd__decap_12
XFILLER_49_253 VPWR VGND VPWR VGND sky130_ef_sc_hd__decap_12
X_1240_ _0562_ _0509_ _0514_ net172 VGND VGND VPWR VPWR _0567_ sky130_fd_sc_hd__nand4_4
XFILLER_2_77 VGND VGND VPWR VPWR sky130_fd_sc_hd__decap_6
XFILLER_1_293 VPWR VGND VPWR VGND sky130_ef_sc_hd__decap_12
X_1171_ _0392_ _0427_ _0430_ _0495_ _0496_ VGND VGND VPWR VPWR _0500_ sky130_fd_sc_hd__o2111ai_4
XFILLER_49_297 VGND VGND VPWR VPWR sky130_fd_sc_hd__decap_3
XFILLER_17_161 VGND VGND VPWR VPWR sky130_fd_sc_hd__decap_3
X_0886_ net19 net83 VGND VGND VPWR VPWR _0033_ sky130_fd_sc_hd__and2_1
X_0955_ _0263_ _0268_ _0269_ _0278_ _0273_ VGND VGND VPWR VPWR _0287_ sky130_fd_sc_hd__a32oi_2
X_1369_ net127 net84 VGND VGND VPWR VPWR _0062_ sky130_fd_sc_hd__and2_1
X_1438_ clknet_3_4__leaf_clk _0064_ VGND VGND VPWR VPWR net34 sky130_fd_sc_hd__dfxtp_1
XFILLER_23_142 VGND VGND VPWR VPWR sky130_fd_sc_hd__fill_2
XFILLER_23_164 VGND VGND VPWR VPWR sky130_fd_sc_hd__fill_1
XFILLER_36_72 VGND VGND VPWR VPWR sky130_fd_sc_hd__fill_1
X_0740_ net358 _0106_ _0111_ _0112_ _0104_ VGND VGND VPWR VPWR _0114_ sky130_fd_sc_hd__a221o_1
Xinput14 b_in[5] VGND VGND VPWR VPWR net14 sky130_fd_sc_hd__clkbuf_1
XFILLER_37_201 VGND VGND VPWR VPWR sky130_fd_sc_hd__fill_1
X_1154_ _0482_ net117 net109 _0410_ VGND VGND VPWR VPWR _0483_ sky130_fd_sc_hd__nand4_4
X_1223_ _0478_ _0521_ _0547_ _0548_ VGND VGND VPWR VPWR _0551_ sky130_fd_sc_hd__a2bb2oi_2
X_1085_ _0409_ _0411_ net109 net119 VGND VGND VPWR VPWR _0415_ sky130_fd_sc_hd__o211a_1
X_0869_ net55 net72 net76 _0216_ net392 VGND VGND VPWR VPWR _0220_ sky130_fd_sc_hd__a41oi_1
X_0938_ net198 net90 net132 net106 _0264_ VGND VGND VPWR VPWR _0271_ sky130_fd_sc_hd__a41o_1
XFILLER_20_178 VGND VGND VPWR VPWR sky130_fd_sc_hd__decap_3
XFILLER_47_93 VGND VGND VPWR VPWR sky130_fd_sc_hd__fill_2
XFILLER_42_281 VGND VGND VPWR VPWR sky130_fd_sc_hd__decap_4
XFILLER_19_278 VGND VGND VPWR VPWR sky130_fd_sc_hd__fill_2
XTAP_TAPCELL_ROW_29_273 VGND VPWR sky130_fd_sc_hd__tapvpwrvgnd_1
X_0723_ net375 net360 net37 product_reg\[0\] VGND VGND VPWR VPWR _0099_ sky130_fd_sc_hd__a22o_1
X_1137_ _0397_ net99 net128 net143 VGND VGND VPWR VPWR _0466_ sky130_fd_sc_hd__a31o_1
X_1206_ _0523_ _0530_ _0531_ VGND VGND VPWR VPWR _0534_ sky130_fd_sc_hd__nand3b_4
XFILLER_40_207 VGND VGND VPWR VPWR sky130_fd_sc_hd__decap_6
XFILLER_33_281 VGND VGND VPWR VPWR sky130_fd_sc_hd__fill_2
X_1068_ net95 net130 net92 net93 VGND VGND VPWR VPWR _0398_ sky130_fd_sc_hd__and4_4
XTAP_TAPCELL_ROW_3_130 VGND VPWR sky130_fd_sc_hd__tapvpwrvgnd_1
XTAP_TAPCELL_ROW_26_254 VGND VPWR sky130_fd_sc_hd__tapvpwrvgnd_1
XFILLER_15_281 VPWR VGND VPWR VGND sky130_ef_sc_hd__decap_12
XFILLER_22_207 VPWR VGND VPWR VGND sky130_ef_sc_hd__decap_12
XFILLER_30_273 VGND VGND VPWR VPWR sky130_fd_sc_hd__fill_1
X_0706_ net20 net83 VGND VGND VPWR VPWR _0034_ sky130_fd_sc_hd__and2_1
XTAP_TAPCELL_ROW_0_111 VGND VPWR sky130_fd_sc_hd__tapvpwrvgnd_1
XFILLER_21_240 VGND VGND VPWR VPWR sky130_fd_sc_hd__decap_4
XFILLER_21_273 VGND VGND VPWR VPWR sky130_fd_sc_hd__decap_6
XFILLER_44_83 VGND VGND VPWR VPWR sky130_fd_sc_hd__fill_1
XFILLER_12_251 VGND VGND VPWR VPWR sky130_fd_sc_hd__fill_1
XFILLER_8_277 VPWR VGND VPWR VGND sky130_ef_sc_hd__decap_12
XFILLER_8_233 VPWR VGND VPWR VGND sky130_ef_sc_hd__decap_12
XFILLER_5_55 VGND VGND VPWR VPWR sky130_fd_sc_hd__fill_1
XFILLER_10_3 VGND VGND VPWR VPWR sky130_fd_sc_hd__decap_8
XTAP_TAPCELL_ROW_45_360 VGND VPWR sky130_fd_sc_hd__tapvpwrvgnd_1
XTAP_TAPCELL_ROW_37_316 VGND VPWR sky130_fd_sc_hd__tapvpwrvgnd_1
XFILLER_35_310 VGND VGND VPWR VPWR sky130_fd_sc_hd__fill_1
XFILLER_49_39 VPWR VGND VPWR VGND sky130_ef_sc_hd__decap_12
Xhold277 net38 VGND VGND VPWR VPWR net412 sky130_fd_sc_hd__dlygate4sd3_1
Xhold255 product_reg\[12\] VGND VGND VPWR VPWR net390 sky130_fd_sc_hd__dlygate4sd3_1
Xhold266 product_reg\[4\] VGND VGND VPWR VPWR net401 sky130_fd_sc_hd__dlygate4sd3_1
XTAP_TAPCELL_ROW_51_396 VGND VPWR sky130_fd_sc_hd__tapvpwrvgnd_1
XFILLER_5_225 VPWR VGND VPWR VGND sky130_ef_sc_hd__decap_12
XFILLER_39_72 VGND VGND VPWR VPWR sky130_fd_sc_hd__decap_8
XFILLER_30_85 VGND VGND VPWR VPWR sky130_fd_sc_hd__decap_6
XFILLER_44_173 VGND VGND VPWR VPWR sky130_fd_sc_hd__decap_4
XFILLER_36_129 VGND VGND VPWR VPWR sky130_fd_sc_hd__decap_8
XFILLER_29_192 VPWR VGND VPWR VGND sky130_ef_sc_hd__decap_12
X_0971_ net90 net133 net5 net155 VGND VGND VPWR VPWR _0303_ sky130_fd_sc_hd__nand4_2
X_1385_ clknet_3_3__leaf_clk _0011_ VGND VGND VPWR VPWR net38 sky130_fd_sc_hd__dfxtp_1
XFILLER_27_107 VGND VGND VPWR VPWR sky130_fd_sc_hd__fill_2
XFILLER_35_184 VGND VGND VPWR VPWR sky130_fd_sc_hd__fill_1
XFILLER_35_19 VGND VGND VPWR VPWR sky130_fd_sc_hd__fill_1
XFILLER_26_195 VGND VGND VPWR VPWR sky130_fd_sc_hd__fill_1
XFILLER_49_265 VGND VGND VPWR VPWR sky130_fd_sc_hd__fill_2
XFILLER_49_210 VPWR VGND VPWR VGND sky130_ef_sc_hd__decap_12
XFILLER_1_261 VPWR VGND VPWR VGND sky130_ef_sc_hd__decap_12
X_1170_ _0392_ net168 _0430_ _0496_ VGND VGND VPWR VPWR _0499_ sky130_fd_sc_hd__o211ai_4
XFILLER_32_154 VGND VGND VPWR VPWR sky130_fd_sc_hd__fill_2
X_0885_ net399 _0230_ net87 _0231_ VGND VGND VPWR VPWR _0032_ sky130_fd_sc_hd__o211a_1
X_0954_ _0084_ _0285_ _0286_ VGND VGND VPWR VPWR _0047_ sky130_fd_sc_hd__a21oi_1
X_1437_ clknet_3_5__leaf_clk _0063_ VGND VGND VPWR VPWR net33 sky130_fd_sc_hd__dfxtp_1
XFILLER_46_29 VPWR VGND VPWR VGND sky130_ef_sc_hd__decap_12
X_1299_ _0623_ _0622_ _0621_ VGND VGND VPWR VPWR _0625_ sky130_fd_sc_hd__nand3_1
X_1368_ _0074_ net82 VGND VGND VPWR VPWR _0061_ sky130_fd_sc_hd__nor2_1
XFILLER_11_305 VGND VGND VPWR VPWR sky130_fd_sc_hd__decap_3
XFILLER_23_110 VGND VGND VPWR VPWR sky130_fd_sc_hd__fill_2
XFILLER_46_224 VGND VGND VPWR VPWR sky130_fd_sc_hd__fill_1
XFILLER_46_213 VGND VGND VPWR VPWR sky130_fd_sc_hd__fill_1
XFILLER_46_257 VPWR VGND VPWR VGND sky130_ef_sc_hd__decap_12
XFILLER_36_95 VGND VGND VPWR VPWR sky130_fd_sc_hd__fill_2
XFILLER_14_154 VGND VGND VPWR VPWR sky130_fd_sc_hd__decap_4
Xinput15 b_in[6] VGND VGND VPWR VPWR net15 sky130_fd_sc_hd__buf_1
XPHY_EDGE_ROW_26_Left_79 VGND VGND VPWR VPWR sky130_fd_sc_hd__decap_3
XFILLER_37_235 VGND VGND VPWR VPWR sky130_fd_sc_hd__decap_6
X_1084_ _0408_ _0410_ _0412_ VGND VGND VPWR VPWR _0414_ sky130_fd_sc_hd__nand3_1
X_1153_ _0408_ _0412_ VGND VGND VPWR VPWR _0482_ sky130_fd_sc_hd__nand2_1
X_1222_ _0537_ _0539_ _0544_ _0545_ VGND VGND VPWR VPWR _0550_ sky130_fd_sc_hd__nand4b_1
X_0868_ net55 _0218_ _0219_ net87 VGND VGND VPWR VPWR _0027_ sky130_fd_sc_hd__o211a_1
X_0799_ _0163_ _0164_ VGND VGND VPWR VPWR _0165_ sky130_fd_sc_hd__and2_1
X_0937_ net108 net129 _0266_ _0267_ VGND VGND VPWR VPWR _0270_ sky130_fd_sc_hd__a22o_1
XFILLER_43_205 VPWR VGND VPWR VGND sky130_ef_sc_hd__decap_12
XFILLER_28_246 VGND VGND VPWR VPWR sky130_fd_sc_hd__decap_6
XFILLER_28_279 VGND VGND VPWR VPWR sky130_fd_sc_hd__fill_2
XFILLER_51_271 VGND VGND VPWR VPWR sky130_fd_sc_hd__fill_2
XFILLER_11_113 VGND VGND VPWR VPWR sky130_fd_sc_hd__decap_4
XFILLER_11_157 VGND VGND VPWR VPWR sky130_fd_sc_hd__decap_8
XFILLER_22_64 VGND VGND VPWR VPWR sky130_fd_sc_hd__decap_3
XFILLER_19_246 VPWR VGND VPWR VGND sky130_ef_sc_hd__decap_12
XFILLER_34_249 VGND VGND VPWR VPWR sky130_fd_sc_hd__decap_3
Xclkbuf_3_4__f_clk clknet_0_clk VGND VGND VPWR VPWR clknet_3_4__leaf_clk sky130_fd_sc_hd__clkbuf_16
XTAP_TAPCELL_ROW_29_274 VGND VPWR sky130_fd_sc_hd__tapvpwrvgnd_1
X_0722_ net48 product_reg\[1\] net37 product_reg\[0\] VGND VGND VPWR VPWR _0098_ sky130_fd_sc_hd__a22oi_4
X_1067_ net177 net130 net93 net92 VGND VGND VPWR VPWR _0397_ sky130_fd_sc_hd__a22o_4
X_1136_ _0395_ _0399_ VGND VGND VPWR VPWR _0465_ sky130_fd_sc_hd__nand2_4
X_1205_ _0526_ _0529_ net102 net118 VGND VGND VPWR VPWR _0533_ sky130_fd_sc_hd__nand4_2
XFILLER_25_249 VPWR VGND VPWR VGND sky130_ef_sc_hd__decap_12
XFILLER_4_109 VPWR VGND VPWR VGND sky130_ef_sc_hd__decap_12
XTAP_TAPCELL_ROW_3_131 VGND VPWR sky130_fd_sc_hd__tapvpwrvgnd_1
XTAP_TAPCELL_ROW_26_255 VGND VPWR sky130_fd_sc_hd__tapvpwrvgnd_1
XFILLER_33_74 VGND VGND VPWR VPWR sky130_fd_sc_hd__decap_3
XFILLER_15_293 VPWR VGND VPWR VGND sky130_ef_sc_hd__decap_12
XFILLER_22_219 VPWR VGND VPWR VGND sky130_ef_sc_hd__decap_12
X_0705_ net20 net19 VGND VGND VPWR VPWR _0085_ sky130_fd_sc_hd__nand2_2
XPHY_EDGE_ROW_29_Left_82 VGND VGND VPWR VPWR sky130_fd_sc_hd__decap_3
XPHY_EDGE_ROW_13_Left_66 VGND VGND VPWR VPWR sky130_fd_sc_hd__decap_3
XTAP_TAPCELL_ROW_48_380 VGND VPWR sky130_fd_sc_hd__tapvpwrvgnd_1
X_1119_ _0321_ _0377_ _0445_ VGND VGND VPWR VPWR _0449_ sky130_fd_sc_hd__or3_1
XTAP_TAPCELL_ROW_0_112 VGND VPWR sky130_fd_sc_hd__tapvpwrvgnd_1
XPHY_EDGE_ROW_17_Right_17 VGND VGND VPWR VPWR sky130_fd_sc_hd__decap_3
XPHY_EDGE_ROW_26_Right_26 VGND VGND VPWR VPWR sky130_fd_sc_hd__decap_3
XFILLER_48_138 VGND VGND VPWR VPWR sky130_fd_sc_hd__fill_2
XPHY_EDGE_ROW_35_Right_35 VGND VGND VPWR VPWR sky130_fd_sc_hd__decap_3
XFILLER_8_245 VGND VGND VPWR VPWR sky130_fd_sc_hd__decap_6
XFILLER_12_230 VGND VGND VPWR VPWR sky130_fd_sc_hd__fill_2
XFILLER_12_263 VPWR VGND VPWR VGND sky130_ef_sc_hd__decap_12
XFILLER_8_289 VPWR VGND VPWR VGND sky130_ef_sc_hd__decap_12
XPHY_EDGE_ROW_44_Right_44 VGND VGND VPWR VPWR sky130_fd_sc_hd__decap_3
XTAP_TAPCELL_ROW_45_361 VGND VPWR sky130_fd_sc_hd__tapvpwrvgnd_1
XTAP_TAPCELL_ROW_37_317 VGND VPWR sky130_fd_sc_hd__tapvpwrvgnd_1
Xhold256 net51 VGND VGND VPWR VPWR net391 sky130_fd_sc_hd__dlygate4sd3_1
Xhold278 net49 VGND VGND VPWR VPWR net413 sky130_fd_sc_hd__dlygate4sd3_1
Xhold267 product_reg\[0\] VGND VGND VPWR VPWR net402 sky130_fd_sc_hd__dlygate4sd3_1
XFILLER_38_182 VPWR VGND VPWR VGND sky130_ef_sc_hd__decap_12
XFILLER_5_237 VPWR VGND VPWR VGND sky130_ef_sc_hd__decap_12
XFILLER_44_141 VGND VGND VPWR VPWR sky130_fd_sc_hd__decap_3
XTAP_TAPCELL_ROW_42_342 VGND VPWR sky130_fd_sc_hd__tapvpwrvgnd_1
X_0970_ net90 net133 net5 net155 VGND VGND VPWR VPWR _0302_ sky130_fd_sc_hd__and4_2
X_1384_ clknet_3_3__leaf_clk _0010_ VGND VGND VPWR VPWR net68 sky130_fd_sc_hd__dfxtp_2
XFILLER_35_130 VGND VGND VPWR VPWR sky130_fd_sc_hd__fill_1
XFILLER_50_188 VGND VGND VPWR VPWR sky130_fd_sc_hd__fill_1
XFILLER_41_111 VGND VGND VPWR VPWR sky130_fd_sc_hd__fill_1
Xrebuffer60 net103 VGND VGND VPWR VPWR net195 sky130_fd_sc_hd__buf_4
XFILLER_18_108 VGND VGND VPWR VPWR sky130_fd_sc_hd__fill_2
XFILLER_49_277 VGND VGND VPWR VPWR sky130_fd_sc_hd__decap_3
XFILLER_49_222 VGND VGND VPWR VPWR sky130_fd_sc_hd__fill_2
XFILLER_1_273 VGND VGND VPWR VPWR sky130_fd_sc_hd__decap_6
XFILLER_32_177 VGND VGND VPWR VPWR sky130_fd_sc_hd__decap_6
XFILLER_32_111 VGND VGND VPWR VPWR sky130_fd_sc_hd__decap_3
X_0884_ _0227_ net416 net399 VGND VGND VPWR VPWR _0231_ sky130_fd_sc_hd__nand3_2
X_0953_ net401 net80 net85 VGND VGND VPWR VPWR _0286_ sky130_fd_sc_hd__o21ai_1
X_1436_ clknet_3_4__leaf_clk _0062_ VGND VGND VPWR VPWR net32 sky130_fd_sc_hd__dfxtp_1
X_1367_ net133 net84 VGND VGND VPWR VPWR _0060_ sky130_fd_sc_hd__and2_1
X_1298_ _0621_ _0622_ _0623_ VGND VGND VPWR VPWR _0624_ sky130_fd_sc_hd__a21oi_1
XFILLER_11_55 VGND VGND VPWR VPWR sky130_fd_sc_hd__fill_1
XFILLER_11_66 VGND VGND VPWR VPWR sky130_fd_sc_hd__fill_2
XFILLER_46_269 VGND VGND VPWR VPWR sky130_fd_sc_hd__decap_8
XFILLER_36_85 VGND VGND VPWR VPWR sky130_fd_sc_hd__fill_1
XPHY_EDGE_ROW_1_Left_54 VGND VGND VPWR VPWR sky130_fd_sc_hd__decap_3
XFILLER_14_122 VGND VGND VPWR VPWR sky130_fd_sc_hd__fill_1
Xinput16 b_in[7] VGND VGND VPWR VPWR net16 sky130_fd_sc_hd__buf_1
X_1221_ _0537_ _0538_ _0546_ VGND VGND VPWR VPWR _0549_ sky130_fd_sc_hd__o21ai_1
X_1083_ _0408_ _0410_ _0412_ VGND VGND VPWR VPWR _0413_ sky130_fd_sc_hd__and3_1
X_1152_ net107 net117 VGND VGND VPWR VPWR _0481_ sky130_fd_sc_hd__nand2_1
X_0936_ _0266_ _0267_ _0264_ VGND VGND VPWR VPWR _0269_ sky130_fd_sc_hd__a21o_1
XTAP_TAPCELL_ROW_15_194 VGND VPWR sky130_fd_sc_hd__tapvpwrvgnd_1
XFILLER_20_103 VGND VGND VPWR VPWR sky130_fd_sc_hd__fill_2
X_0798_ product_reg\[12\] net40 VGND VGND VPWR VPWR _0164_ sky130_fd_sc_hd__nand2_1
X_0867_ net55 net371 net76 _0216_ VGND VGND VPWR VPWR _0219_ sky130_fd_sc_hd__nand4_1
XPHY_EDGE_ROW_43_Left_96 VGND VGND VPWR VPWR sky130_fd_sc_hd__decap_3
X_1419_ clknet_3_5__leaf_clk _0045_ VGND VGND VPWR VPWR product_reg\[2\] sky130_fd_sc_hd__dfxtp_1
XFILLER_28_225 VGND VGND VPWR VPWR sky130_fd_sc_hd__decap_3
XFILLER_43_217 VGND VGND VPWR VPWR sky130_fd_sc_hd__decap_6
XFILLER_11_169 VGND VGND VPWR VPWR sky130_fd_sc_hd__fill_2
XFILLER_0_3 VPWR VGND VPWR VGND sky130_ef_sc_hd__decap_12
XFILLER_47_51 VGND VGND VPWR VPWR sky130_fd_sc_hd__decap_4
XFILLER_19_258 VPWR VGND VPWR VGND sky130_ef_sc_hd__decap_12
XTAP_TAPCELL_ROW_29_275 VGND VPWR sky130_fd_sc_hd__tapvpwrvgnd_1
XFILLER_8_67 VGND VGND VPWR VPWR sky130_fd_sc_hd__fill_1
X_0721_ product_reg\[2\] net59 VGND VGND VPWR VPWR _0097_ sky130_fd_sc_hd__or2_1
XFILLER_6_195 VGND VGND VPWR VPWR sky130_fd_sc_hd__fill_1
X_1204_ _0076_ _0078_ _0525_ _0528_ VGND VGND VPWR VPWR _0532_ sky130_fd_sc_hd__o22ai_2
X_1066_ net95 net130 net93 net92 VGND VGND VPWR VPWR _0396_ sky130_fd_sc_hd__a22oi_4
X_1135_ _0074_ _0080_ _0329_ _0460_ VGND VGND VPWR VPWR _0464_ sky130_fd_sc_hd__o31a_1
X_0919_ _0250_ _0251_ _0252_ VGND VGND VPWR VPWR _0253_ sky130_fd_sc_hd__a21oi_1
XFILLER_0_305 VGND VGND VPWR VPWR sky130_fd_sc_hd__decap_3
XFILLER_48_309 VGND VGND VPWR VPWR sky130_fd_sc_hd__fill_2
XTAP_TAPCELL_ROW_3_132 VGND VPWR sky130_fd_sc_hd__tapvpwrvgnd_1
XFILLER_16_239 VGND VGND VPWR VPWR sky130_fd_sc_hd__decap_3
XFILLER_33_64 VGND VGND VPWR VPWR sky130_fd_sc_hd__decap_6
XTAP_TAPCELL_ROW_26_256 VGND VPWR sky130_fd_sc_hd__tapvpwrvgnd_1
XFILLER_33_97 VGND VGND VPWR VPWR sky130_fd_sc_hd__fill_2
XFILLER_30_220 VGND VGND VPWR VPWR sky130_fd_sc_hd__decap_4
X_0704_ net20 net19 VGND VGND VPWR VPWR _0084_ sky130_fd_sc_hd__and2_1
XTAP_TAPCELL_ROW_0_113 VGND VPWR sky130_fd_sc_hd__tapvpwrvgnd_1
X_1049_ _0378_ _0379_ _0000_ _0232_ net389 VGND VGND VPWR VPWR _0049_ sky130_fd_sc_hd__a32o_1
X_1118_ _0442_ _0446_ _0445_ VGND VGND VPWR VPWR _0448_ sky130_fd_sc_hd__o21bai_1
XFILLER_21_220 VGND VGND VPWR VPWR sky130_fd_sc_hd__decap_4
XFILLER_0_113 VPWR VGND VPWR VGND sky130_ef_sc_hd__decap_12
XFILLER_28_20 VGND VGND VPWR VPWR sky130_fd_sc_hd__fill_2
XFILLER_44_41 VPWR VGND VPWR VGND sky130_ef_sc_hd__decap_12
XFILLER_12_275 VPWR VGND VPWR VGND sky130_ef_sc_hd__decap_12
XPHY_EDGE_ROW_30_Left_83 VGND VGND VPWR VPWR sky130_fd_sc_hd__decap_3
XFILLER_5_57 VPWR VGND VPWR VGND sky130_ef_sc_hd__decap_12
XFILLER_39_117 VGND VGND VPWR VPWR sky130_fd_sc_hd__decap_4
XTAP_TAPCELL_ROW_37_318 VGND VPWR sky130_fd_sc_hd__tapvpwrvgnd_1
XTAP_TAPCELL_ROW_45_362 VGND VPWR sky130_fd_sc_hd__tapvpwrvgnd_1
Xhold257 net56 VGND VGND VPWR VPWR net392 sky130_fd_sc_hd__dlygate4sd3_1
Xhold279 net65 VGND VGND VPWR VPWR net414 sky130_fd_sc_hd__dlygate4sd3_1
Xhold268 net37 VGND VGND VPWR VPWR net403 sky130_fd_sc_hd__dlygate4sd3_1
XFILLER_38_194 VGND VGND VPWR VPWR sky130_fd_sc_hd__fill_2
XFILLER_5_249 VPWR VGND VPWR VGND sky130_ef_sc_hd__decap_12
XFILLER_5_205 VPWR VGND VPWR VGND sky130_ef_sc_hd__decap_12
XFILLER_39_85 VGND VGND VPWR VPWR sky130_fd_sc_hd__decap_3
XFILLER_44_197 VGND VGND VPWR VPWR sky130_fd_sc_hd__decap_8
XTAP_TAPCELL_ROW_42_343 VGND VPWR sky130_fd_sc_hd__tapvpwrvgnd_1
XFILLER_29_183 VGND VGND VPWR VPWR sky130_fd_sc_hd__fill_1
X_1383_ clknet_3_1__leaf_clk _0009_ VGND VGND VPWR VPWR net67 sky130_fd_sc_hd__dfxtp_1
Xrebuffer61 net103 VGND VGND VPWR VPWR net196 sky130_fd_sc_hd__buf_6
Xrebuffer50 _0477_ VGND VGND VPWR VPWR net185 sky130_fd_sc_hd__dlymetal6s4s_1
XFILLER_41_167 VGND VGND VPWR VPWR sky130_fd_sc_hd__fill_1
XFILLER_49_201 VGND VGND VPWR VPWR sky130_fd_sc_hd__fill_1
XFILLER_49_289 VGND VGND VPWR VPWR sky130_fd_sc_hd__decap_3
XFILLER_32_123 VGND VGND VPWR VPWR sky130_fd_sc_hd__fill_1
X_0952_ _0258_ _0283_ VGND VGND VPWR VPWR _0285_ sky130_fd_sc_hd__xnor2_1
XFILLER_17_175 VGND VGND VPWR VPWR sky130_fd_sc_hd__decap_4
X_0883_ net82 _0230_ _0229_ VGND VGND VPWR VPWR _0031_ sky130_fd_sc_hd__nor3b_1
X_1435_ clknet_3_5__leaf_clk _0061_ VGND VGND VPWR VPWR net31 sky130_fd_sc_hd__dfxtp_1
X_1366_ net91 net84 VGND VGND VPWR VPWR _0059_ sky130_fd_sc_hd__and2_1
X_1297_ _0595_ _0591_ _0594_ VGND VGND VPWR VPWR _0623_ sky130_fd_sc_hd__o21ai_1
XFILLER_36_53 VGND VGND VPWR VPWR sky130_fd_sc_hd__fill_1
XFILLER_52_85 VGND VGND VPWR VPWR sky130_fd_sc_hd__decap_3
XFILLER_52_41 VPWR VGND VPWR VGND sky130_ef_sc_hd__decap_12
Xinput17 clear_acc VGND VGND VPWR VPWR net17 sky130_fd_sc_hd__clkbuf_2
X_1220_ _0537_ _0539_ _0546_ VGND VGND VPWR VPWR _0548_ sky130_fd_sc_hd__nand3b_1
X_1151_ net110 net115 VGND VGND VPWR VPWR _0480_ sky130_fd_sc_hd__nand2_1
X_1082_ net106 net126 net195 net122 VGND VGND VPWR VPWR _0412_ sky130_fd_sc_hd__nand4_4
X_0866_ net72 net76 _0216_ VGND VGND VPWR VPWR _0218_ sky130_fd_sc_hd__and3_1
X_0935_ _0264_ _0266_ _0267_ VGND VGND VPWR VPWR _0268_ sky130_fd_sc_hd__nand3_1
XTAP_TAPCELL_ROW_15_195 VGND VPWR sky130_fd_sc_hd__tapvpwrvgnd_1
X_0797_ product_reg\[12\] net40 VGND VGND VPWR VPWR _0163_ sky130_fd_sc_hd__or2_1
X_1349_ _0647_ _0648_ _0665_ _0667_ VGND VGND VPWR VPWR _0672_ sky130_fd_sc_hd__nor4_1
X_1418_ clknet_3_5__leaf_clk _0044_ VGND VGND VPWR VPWR product_reg\[1\] sky130_fd_sc_hd__dfxtp_4
XFILLER_28_204 VGND VGND VPWR VPWR sky130_fd_sc_hd__decap_4
XFILLER_28_215 VGND VGND VPWR VPWR sky130_fd_sc_hd__decap_4
XFILLER_7_119 VGND VGND VPWR VPWR sky130_fd_sc_hd__fill_1
XFILLER_22_55 VGND VGND VPWR VPWR sky130_fd_sc_hd__fill_2
XFILLER_22_88 VGND VGND VPWR VPWR sky130_fd_sc_hd__fill_1
XFILLER_19_204 VGND VGND VPWR VPWR sky130_fd_sc_hd__decap_6
XFILLER_34_229 VPWR VGND VPWR VGND sky130_ef_sc_hd__decap_12
XFILLER_42_240 VPWR VGND VPWR VGND sky130_ef_sc_hd__decap_12
X_0720_ product_reg\[2\] net59 VGND VGND VPWR VPWR _0096_ sky130_fd_sc_hd__nor2_1
XFILLER_6_141 VPWR VGND VPWR VGND sky130_ef_sc_hd__decap_12
X_1134_ net130 net128 net177 net93 VGND VGND VPWR VPWR _0463_ sky130_fd_sc_hd__nand4_4
X_1203_ _0525_ _0528_ _0524_ VGND VGND VPWR VPWR _0531_ sky130_fd_sc_hd__o21bai_2
XFILLER_33_240 VGND VGND VPWR VPWR sky130_fd_sc_hd__fill_1
X_1065_ net128 net99 VGND VGND VPWR VPWR _0395_ sky130_fd_sc_hd__nand2_4
XFILLER_18_270 VPWR VGND VPWR VGND sky130_ef_sc_hd__decap_12
X_0849_ net49 net370 _0204_ net81 _0206_ VGND VGND VPWR VPWR _0021_ sky130_fd_sc_hd__a311oi_1
X_0918_ _0239_ net135 net129 _0237_ VGND VGND VPWR VPWR _0252_ sky130_fd_sc_hd__a31o_1
XFILLER_33_54 VGND VGND VPWR VPWR sky130_fd_sc_hd__fill_2
XFILLER_24_251 VGND VGND VPWR VPWR sky130_fd_sc_hd__fill_1
XTAP_TAPCELL_ROW_26_257 VGND VPWR sky130_fd_sc_hd__tapvpwrvgnd_1
XFILLER_3_111 VGND VGND VPWR VPWR sky130_fd_sc_hd__fill_1
X_0703_ net17 net18 VGND VGND VPWR VPWR _0083_ sky130_fd_sc_hd__or2_1
X_1117_ _0440_ _0443_ _0375_ VGND VGND VPWR VPWR _0447_ sky130_fd_sc_hd__nand3_1
XTAP_TAPCELL_ROW_0_114 VGND VPWR sky130_fd_sc_hd__tapvpwrvgnd_1
X_1048_ _0320_ _0376_ _0374_ VGND VGND VPWR VPWR _0379_ sky130_fd_sc_hd__nand3_4
XPHY_EDGE_ROW_3_Right_3 VGND VGND VPWR VPWR sky130_fd_sc_hd__decap_3
XTAP_TAPCELL_ROW_23_238 VGND VPWR sky130_fd_sc_hd__tapvpwrvgnd_1
XTAP_TAPCELL_ROW_31_282 VGND VPWR sky130_fd_sc_hd__tapvpwrvgnd_1
XFILLER_48_129 VGND VGND VPWR VPWR sky130_fd_sc_hd__fill_1
XFILLER_0_125 VPWR VGND VPWR VGND sky130_ef_sc_hd__decap_12
XFILLER_0_169 VPWR VGND VPWR VGND sky130_ef_sc_hd__decap_12
XFILLER_28_32 VGND VGND VPWR VPWR sky130_fd_sc_hd__decap_3
XFILLER_44_53 VPWR VGND VPWR VGND sky130_ef_sc_hd__decap_12
XFILLER_12_287 VPWR VGND VPWR VGND sky130_ef_sc_hd__decap_12
XFILLER_5_69 VPWR VGND VPWR VGND sky130_ef_sc_hd__decap_12
XTAP_TAPCELL_ROW_37_319 VGND VPWR sky130_fd_sc_hd__tapvpwrvgnd_1
XTAP_TAPCELL_ROW_45_363 VGND VPWR sky130_fd_sc_hd__tapvpwrvgnd_1
Xhold258 product_reg\[3\] VGND VGND VPWR VPWR net393 sky130_fd_sc_hd__dlygate4sd3_1
Xhold269 _0087_ VGND VGND VPWR VPWR net404 sky130_fd_sc_hd__dlygate4sd3_1
XFILLER_5_217 VGND VGND VPWR VPWR sky130_fd_sc_hd__decap_6
XFILLER_29_140 VGND VGND VPWR VPWR sky130_fd_sc_hd__fill_1
XTAP_TAPCELL_ROW_42_344 VGND VPWR sky130_fd_sc_hd__tapvpwrvgnd_1
X_1382_ clknet_3_6__leaf_clk _0008_ VGND VGND VPWR VPWR net66 sky130_fd_sc_hd__dfxtp_1
XFILLER_50_102 VGND VGND VPWR VPWR sky130_fd_sc_hd__decap_8
XFILLER_35_176 VGND VGND VPWR VPWR sky130_fd_sc_hd__decap_8
XFILLER_23_305 VGND VGND VPWR VPWR sky130_fd_sc_hd__fill_2
XFILLER_50_146 VGND VGND VPWR VPWR sky130_fd_sc_hd__fill_2
XFILLER_2_209 VPWR VGND VPWR VGND sky130_ef_sc_hd__decap_12
XFILLER_41_113 VPWR VGND VPWR VGND sky130_ef_sc_hd__decap_12
Xrebuffer62 net196 VGND VGND VPWR VPWR net197 sky130_fd_sc_hd__buf_4
Xrebuffer40 _0427_ VGND VGND VPWR VPWR net175 sky130_fd_sc_hd__dlymetal6s2s_1
Xrebuffer51 net189 VGND VGND VPWR VPWR net186 sky130_fd_sc_hd__buf_1
XFILLER_41_54 VGND VGND VPWR VPWR sky130_fd_sc_hd__fill_2
XFILLER_41_10 VGND VGND VPWR VPWR sky130_fd_sc_hd__decap_4
Xrebuffer163 _0396_ VGND VGND VPWR VPWR net298 sky130_fd_sc_hd__buf_6
XFILLER_2_15 VPWR VGND VPWR VGND sky130_ef_sc_hd__decap_12
XFILLER_17_110 VGND VGND VPWR VPWR sky130_fd_sc_hd__fill_2
X_0882_ _0226_ net58 net60 VGND VGND VPWR VPWR _0230_ sky130_fd_sc_hd__and3_1
X_0951_ _0256_ _0257_ _0282_ net75 VGND VGND VPWR VPWR _0284_ sky130_fd_sc_hd__nand4_2
X_1365_ _0678_ _0683_ _0685_ _0686_ VGND VGND VPWR VPWR _0058_ sky130_fd_sc_hd__a31oi_1
X_1296_ _0616_ _0618_ _0620_ VGND VGND VPWR VPWR _0622_ sky130_fd_sc_hd__nand3b_1
X_1434_ clknet_3_5__leaf_clk _0060_ VGND VGND VPWR VPWR net30 sky130_fd_sc_hd__dfxtp_1
XFILLER_23_113 VGND VGND VPWR VPWR sky130_fd_sc_hd__fill_2
XFILLER_52_64 VPWR VGND VPWR VGND sky130_ef_sc_hd__decap_12
XFILLER_52_53 VGND VGND VPWR VPWR sky130_fd_sc_hd__decap_3
Xinput18 reset VGND VGND VPWR VPWR net18 sky130_fd_sc_hd__clkbuf_2
XFILLER_6_301 VGND VGND VPWR VPWR sky130_fd_sc_hd__decap_6
XFILLER_14_168 VGND VGND VPWR VPWR sky130_fd_sc_hd__decap_4
XTAP_TAPCELL_ROW_9_161 VGND VPWR sky130_fd_sc_hd__tapvpwrvgnd_1
X_1150_ _0467_ _0471_ _0423_ net181 _0474_ VGND VGND VPWR VPWR _0479_ sky130_fd_sc_hd__o221ai_4
XFILLER_45_293 VGND VGND VPWR VPWR sky130_fd_sc_hd__fill_2
X_1081_ net106 net126 net195 net122 VGND VGND VPWR VPWR _0411_ sky130_fd_sc_hd__and4_1
X_0865_ _0215_ _0217_ net87 VGND VGND VPWR VPWR _0026_ sky130_fd_sc_hd__and3_1
X_0934_ net106 net90 net132 net197 VGND VGND VPWR VPWR _0267_ sky130_fd_sc_hd__nand4_4
XTAP_TAPCELL_ROW_15_196 VGND VPWR sky130_fd_sc_hd__tapvpwrvgnd_1
X_0796_ _0161_ _0070_ _0160_ _0162_ net83 VGND VGND VPWR VPWR _0012_ sky130_fd_sc_hd__o311a_1
X_1417_ clknet_3_4__leaf_clk _0043_ VGND VGND VPWR VPWR product_reg\[0\] sky130_fd_sc_hd__dfxtp_4
X_1348_ _0669_ _0670_ net80 _0671_ VGND VGND VPWR VPWR _0056_ sky130_fd_sc_hd__a31oi_1
X_1279_ _0576_ _0579_ VGND VGND VPWR VPWR _0605_ sky130_fd_sc_hd__nand2_1
XFILLER_6_153 VPWR VGND VPWR VGND sky130_ef_sc_hd__decap_12
XTAP_TAPCELL_ROW_12_177 VGND VPWR sky130_fd_sc_hd__tapvpwrvgnd_1
XFILLER_6_197 VPWR VGND VPWR VGND sky130_ef_sc_hd__decap_12
X_1064_ _0327_ _0326_ _0331_ VGND VGND VPWR VPWR _0394_ sky130_fd_sc_hd__o21a_1
X_1133_ net130 net128 net177 net94 VGND VGND VPWR VPWR _0462_ sky130_fd_sc_hd__and4_1
X_1202_ _0076_ _0078_ _0526_ _0529_ VGND VGND VPWR VPWR _0530_ sky130_fd_sc_hd__o211ai_2
XFILLER_25_219 VGND VGND VPWR VPWR sky130_fd_sc_hd__decap_4
XFILLER_18_282 VPWR VGND VPWR VGND sky130_ef_sc_hd__decap_12
X_0779_ _0145_ _0146_ _0147_ VGND VGND VPWR VPWR _0148_ sky130_fd_sc_hd__a21oi_1
X_0848_ net370 _0204_ net413 VGND VGND VPWR VPWR _0206_ sky130_fd_sc_hd__a21oi_2
X_0917_ _0249_ net111 net129 _0247_ VGND VGND VPWR VPWR _0251_ sky130_fd_sc_hd__nand4_2
XFILLER_16_219 VGND VGND VPWR VPWR sky130_fd_sc_hd__decap_6
XTAP_TAPCELL_ROW_26_258 VGND VPWR sky130_fd_sc_hd__tapvpwrvgnd_1
XFILLER_24_285 VGND VGND VPWR VPWR sky130_fd_sc_hd__decap_6
XFILLER_3_167 VGND VGND VPWR VPWR sky130_fd_sc_hd__fill_1
X_0702_ net17 net18 VGND VGND VPWR VPWR _0082_ sky130_fd_sc_hd__nor2_1
X_1116_ _0440_ _0375_ VGND VGND VPWR VPWR _0446_ sky130_fd_sc_hd__nand2_1
X_1047_ _0374_ _0376_ _0320_ VGND VGND VPWR VPWR _0378_ sky130_fd_sc_hd__a21o_1
XTAP_TAPCELL_ROW_0_115 VGND VPWR sky130_fd_sc_hd__tapvpwrvgnd_1
XFILLER_21_244 VGND VGND VPWR VPWR sky130_fd_sc_hd__fill_1
XTAP_TAPCELL_ROW_23_239 VGND VPWR sky130_fd_sc_hd__tapvpwrvgnd_1
XTAP_TAPCELL_ROW_31_283 VGND VPWR sky130_fd_sc_hd__tapvpwrvgnd_1
XFILLER_0_137 VGND VGND VPWR VPWR sky130_fd_sc_hd__decap_3
XFILLER_44_65 VPWR VGND VPWR VGND sky130_ef_sc_hd__decap_12
XFILLER_5_15 VPWR VGND VPWR VGND sky130_ef_sc_hd__decap_12
XFILLER_12_299 VGND VGND VPWR VPWR sky130_fd_sc_hd__decap_8
XFILLER_47_185 VGND VGND VPWR VPWR sky130_fd_sc_hd__decap_3
XPHY_EDGE_ROW_13_Right_13 VGND VGND VPWR VPWR sky130_fd_sc_hd__decap_3
XPHY_EDGE_ROW_22_Right_22 VGND VGND VPWR VPWR sky130_fd_sc_hd__decap_3
Xhold259 product_reg\[13\] VGND VGND VPWR VPWR net394 sky130_fd_sc_hd__dlygate4sd3_1
XFILLER_7_281 VPWR VGND VPWR VGND sky130_ef_sc_hd__decap_12
XFILLER_38_141 VGND VGND VPWR VPWR sky130_fd_sc_hd__fill_1
XPHY_EDGE_ROW_31_Right_31 VGND VGND VPWR VPWR sky130_fd_sc_hd__decap_3
XPHY_EDGE_ROW_40_Right_40 VGND VGND VPWR VPWR sky130_fd_sc_hd__decap_3
XFILLER_30_45 VGND VGND VPWR VPWR sky130_fd_sc_hd__decap_4
XTAP_TAPCELL_ROW_42_345 VGND VPWR sky130_fd_sc_hd__tapvpwrvgnd_1
XFILLER_4_251 VGND VGND VPWR VPWR sky130_fd_sc_hd__fill_1
X_1381_ clknet_3_4__leaf_clk _0007_ VGND VGND VPWR VPWR net65 sky130_fd_sc_hd__dfxtp_1
XFILLER_35_166 VGND VGND VPWR VPWR sky130_fd_sc_hd__fill_2
Xrebuffer30 net163 VGND VGND VPWR VPWR net165 sky130_fd_sc_hd__dlygate4sd1_1
Xrebuffer63 net197 VGND VGND VPWR VPWR net198 sky130_fd_sc_hd__dlymetal6s2s_1
Xrebuffer41 net95 VGND VGND VPWR VPWR net176 sky130_fd_sc_hd__buf_1
Xrebuffer52 _0479_ VGND VGND VPWR VPWR net187 sky130_fd_sc_hd__buf_6
XFILLER_41_125 VPWR VGND VPWR VGND sky130_ef_sc_hd__decap_12
XFILLER_41_22 VPWR VGND VPWR VGND sky130_ef_sc_hd__decap_12
XFILLER_25_67 VGND VGND VPWR VPWR sky130_fd_sc_hd__decap_4
XFILLER_25_78 VGND VGND VPWR VPWR sky130_fd_sc_hd__fill_2
XFILLER_41_99 VPWR VGND VPWR VGND sky130_ef_sc_hd__decap_12
XFILLER_49_225 VPWR VGND VPWR VGND sky130_ef_sc_hd__decap_12
XFILLER_2_27 VGND VGND VPWR VPWR sky130_fd_sc_hd__fill_1
X_0881_ net58 net57 _0224_ net60 VGND VGND VPWR VPWR _0229_ sky130_fd_sc_hd__a31o_1
XFILLER_20_309 VGND VGND VPWR VPWR sky130_fd_sc_hd__fill_2
X_0950_ _0281_ _0282_ VGND VGND VPWR VPWR _0283_ sky130_fd_sc_hd__nand2_1
XFILLER_49_3 VPWR VGND VPWR VGND sky130_ef_sc_hd__decap_12
X_1433_ clknet_3_4__leaf_clk _0059_ VGND VGND VPWR VPWR net29 sky130_fd_sc_hd__dfxtp_1
X_1364_ product_reg\[15\] net80 net83 VGND VGND VPWR VPWR _0686_ sky130_fd_sc_hd__o21ai_1
X_1295_ _0616_ _0617_ _0620_ VGND VGND VPWR VPWR _0621_ sky130_fd_sc_hd__o21bai_1
XFILLER_23_136 VGND VGND VPWR VPWR sky130_fd_sc_hd__fill_1
XFILLER_23_169 VGND VGND VPWR VPWR sky130_fd_sc_hd__decap_6
XPHY_EDGE_ROW_52_Left_105 VGND VGND VPWR VPWR sky130_fd_sc_hd__decap_3
XFILLER_11_47 VGND VGND VPWR VPWR sky130_fd_sc_hd__decap_8
XFILLER_31_180 VGND VGND VPWR VPWR sky130_fd_sc_hd__fill_1
XFILLER_31_191 VGND VGND VPWR VPWR sky130_fd_sc_hd__decap_8
XFILLER_52_76 VGND VGND VPWR VPWR sky130_fd_sc_hd__decap_4
Xinput19 v_a_in VGND VGND VPWR VPWR net19 sky130_fd_sc_hd__clkbuf_2
XFILLER_14_158 VGND VGND VPWR VPWR sky130_fd_sc_hd__fill_1
XTAP_TAPCELL_ROW_9_162 VGND VPWR sky130_fd_sc_hd__tapvpwrvgnd_1
X_1080_ net125 net195 net122 net106 VGND VGND VPWR VPWR _0410_ sky130_fd_sc_hd__a22o_1
X_0864_ net77 _0196_ net76 _0216_ VGND VGND VPWR VPWR _0217_ sky130_fd_sc_hd__nand4_1
X_0795_ net79 net39 VGND VGND VPWR VPWR _0162_ sky130_fd_sc_hd__or2_1
X_0933_ net105 net133 net197 net90 VGND VGND VPWR VPWR _0266_ sky130_fd_sc_hd__a22o_4
XTAP_TAPCELL_ROW_15_197 VGND VPWR sky130_fd_sc_hd__tapvpwrvgnd_1
X_1347_ net394 net80 net83 VGND VGND VPWR VPWR _0671_ sky130_fd_sc_hd__o21ai_1
X_1416_ clknet_3_2__leaf_clk _0042_ VGND VGND VPWR VPWR net28 sky130_fd_sc_hd__dfxtp_1
XFILLER_3_81 VPWR VGND VPWR VGND sky130_ef_sc_hd__decap_12
X_1278_ _0604_ _0602_ net406 _0232_ VGND VGND VPWR VPWR _0053_ sky130_fd_sc_hd__a2bb2o_4
XFILLER_11_117 VGND VGND VPWR VPWR sky130_fd_sc_hd__fill_1
XPHY_EDGE_ROW_5_Left_58 VGND VGND VPWR VPWR sky130_fd_sc_hd__decap_3
XFILLER_3_305 VGND VGND VPWR VPWR sky130_fd_sc_hd__decap_6
Xfanout130 net10 VGND VGND VPWR VPWR net130 sky130_fd_sc_hd__buf_4
XFILLER_42_264 VGND VGND VPWR VPWR sky130_fd_sc_hd__fill_1
XFILLER_8_15 VPWR VGND VPWR VGND sky130_ef_sc_hd__decap_12
XFILLER_27_261 VGND VGND VPWR VPWR sky130_fd_sc_hd__decap_3
XFILLER_6_165 VPWR VGND VPWR VGND sky130_ef_sc_hd__decap_12
XFILLER_6_121 VPWR VGND VPWR VGND sky130_ef_sc_hd__decap_12
XFILLER_10_183 VGND VGND VPWR VPWR sky130_fd_sc_hd__fill_2
XTAP_TAPCELL_ROW_12_178 VGND VPWR sky130_fd_sc_hd__tapvpwrvgnd_1
X_1201_ net125 net121 net96 net99 VGND VGND VPWR VPWR _0529_ sky130_fd_sc_hd__nand4_4
X_1063_ _0326_ net169 _0331_ VGND VGND VPWR VPWR _0393_ sky130_fd_sc_hd__o21ai_4
X_1132_ net128 net93 VGND VGND VPWR VPWR _0461_ sky130_fd_sc_hd__nand2_2
XFILLER_18_294 VPWR VGND VPWR VGND sky130_ef_sc_hd__decap_12
XFILLER_33_231 VGND VGND VPWR VPWR sky130_fd_sc_hd__fill_1
X_0916_ net129 net111 _0247_ _0249_ VGND VGND VPWR VPWR _0250_ sky130_fd_sc_hd__a22o_1
X_0847_ _0203_ _0205_ net86 VGND VGND VPWR VPWR _0020_ sky130_fd_sc_hd__and3_1
X_0778_ _0138_ _0144_ VGND VGND VPWR VPWR _0147_ sky130_fd_sc_hd__and2_1
XFILLER_17_57 VGND VGND VPWR VPWR sky130_fd_sc_hd__decap_3
XTAP_TAPCELL_ROW_26_259 VGND VPWR sky130_fd_sc_hd__tapvpwrvgnd_1
XFILLER_3_113 VPWR VGND VPWR VGND sky130_ef_sc_hd__decap_12
X_0701_ net114 VGND VGND VPWR VPWR _0081_ sky130_fd_sc_hd__inv_2
XFILLER_31_3 VPWR VGND VPWR VGND sky130_ef_sc_hd__decap_12
X_1115_ _0443_ _0440_ _0375_ VGND VGND VPWR VPWR _0445_ sky130_fd_sc_hd__a21oi_2
X_1046_ _0374_ _0376_ VGND VGND VPWR VPWR _0377_ sky130_fd_sc_hd__nand2_1
XFILLER_0_82 VGND VGND VPWR VPWR sky130_fd_sc_hd__fill_2
XTAP_TAPCELL_ROW_0_116 VGND VPWR sky130_fd_sc_hd__tapvpwrvgnd_1
XFILLER_21_201 VGND VGND VPWR VPWR sky130_fd_sc_hd__decap_4
XFILLER_21_267 VGND VGND VPWR VPWR sky130_fd_sc_hd__fill_1
XTAP_TAPCELL_ROW_31_284 VGND VPWR sky130_fd_sc_hd__tapvpwrvgnd_1
XFILLER_44_77 VGND VGND VPWR VPWR sky130_fd_sc_hd__decap_6
XFILLER_5_27 VPWR VGND VPWR VGND sky130_ef_sc_hd__decap_12
XPHY_EDGE_ROW_8_Left_61 VGND VGND VPWR VPWR sky130_fd_sc_hd__decap_3
XFILLER_47_197 VGND VGND VPWR VPWR sky130_fd_sc_hd__decap_3
XFILLER_47_164 VGND VGND VPWR VPWR sky130_fd_sc_hd__decap_4
XFILLER_47_153 VGND VGND VPWR VPWR sky130_fd_sc_hd__fill_1
XFILLER_7_293 VPWR VGND VPWR VGND sky130_ef_sc_hd__decap_12
XFILLER_38_197 VPWR VGND VPWR VGND sky130_ef_sc_hd__decap_12
XFILLER_38_120 VGND VGND VPWR VPWR sky130_fd_sc_hd__decap_8
XTAP_TAPCELL_ROW_36_310 VGND VPWR sky130_fd_sc_hd__tapvpwrvgnd_1
X_1029_ _0353_ _0355_ _0357_ VGND VGND VPWR VPWR _0360_ sky130_fd_sc_hd__and3_1
XFILLER_30_35 VGND VGND VPWR VPWR sky130_fd_sc_hd__decap_3
XFILLER_44_101 VGND VGND VPWR VPWR sky130_fd_sc_hd__decap_3
XPHY_EDGE_ROW_34_Left_87 VGND VGND VPWR VPWR sky130_fd_sc_hd__decap_3
XTAP_TAPCELL_ROW_50_390 VGND VPWR sky130_fd_sc_hd__tapvpwrvgnd_1
XTAP_TAPCELL_ROW_42_346 VGND VPWR sky130_fd_sc_hd__tapvpwrvgnd_1
X_1380_ clknet_3_6__leaf_clk _0006_ VGND VGND VPWR VPWR net64 sky130_fd_sc_hd__dfxtp_1
XFILLER_35_101 VGND VGND VPWR VPWR sky130_fd_sc_hd__decap_8
XFILLER_50_126 VPWR VGND VPWR VGND sky130_ef_sc_hd__decap_12
XFILLER_35_189 VPWR VGND VPWR VGND sky130_ef_sc_hd__decap_12
Xrebuffer64 _0498_ VGND VGND VPWR VPWR net199 sky130_fd_sc_hd__dlygate4sd1_1
XFILLER_14_307 VGND VGND VPWR VPWR sky130_fd_sc_hd__fill_1
Xrebuffer53 _0455_ VGND VGND VPWR VPWR net188 sky130_fd_sc_hd__dlygate4sd1_1
Xrebuffer20 net100 VGND VGND VPWR VPWR net155 sky130_fd_sc_hd__buf_8
Xrebuffer31 net183 VGND VGND VPWR VPWR net166 sky130_fd_sc_hd__buf_6
XFILLER_25_24 VGND VGND VPWR VPWR sky130_fd_sc_hd__fill_1
XFILLER_41_137 VGND VGND VPWR VPWR sky130_fd_sc_hd__decap_4
XFILLER_41_34 VPWR VGND VPWR VGND sky130_ef_sc_hd__decap_12
XFILLER_25_46 VGND VGND VPWR VPWR sky130_fd_sc_hd__decap_3
XFILLER_9_3 VPWR VGND VPWR VGND sky130_ef_sc_hd__decap_12
XFILLER_49_237 VGND VGND VPWR VPWR sky130_fd_sc_hd__decap_3
X_0880_ net58 _0226_ net87 _0228_ VGND VGND VPWR VPWR _0030_ sky130_fd_sc_hd__o211a_1
XFILLER_40_192 VGND VGND VPWR VPWR sky130_fd_sc_hd__decap_4
X_1432_ clknet_3_2__leaf_clk _0058_ VGND VGND VPWR VPWR product_reg\[15\] sky130_fd_sc_hd__dfxtp_1
X_1363_ _0080_ net89 _0633_ net19 net20 VGND VGND VPWR VPWR _0685_ sky130_fd_sc_hd__o311a_1
X_1294_ net102 net116 _0526_ _0571_ _0619_ VGND VGND VPWR VPWR _0620_ sky130_fd_sc_hd__a41o_1
XFILLER_11_15 VGND VGND VPWR VPWR sky130_fd_sc_hd__decap_4
XFILLER_39_281 VGND VGND VPWR VPWR sky130_fd_sc_hd__fill_2
XFILLER_22_170 VGND VGND VPWR VPWR sky130_fd_sc_hd__decap_4
XTAP_TAPCELL_ROW_9_163 VGND VPWR sky130_fd_sc_hd__tapvpwrvgnd_1
XPHY_EDGE_ROW_37_Left_90 VGND VGND VPWR VPWR sky130_fd_sc_hd__decap_3
XFILLER_28_9 VGND VGND VPWR VPWR sky130_fd_sc_hd__decap_4
X_0932_ net105 net132 net197 net90 VGND VGND VPWR VPWR _0265_ sky130_fd_sc_hd__a22oi_4
XTAP_TAPCELL_ROW_15_198 VGND VPWR sky130_fd_sc_hd__tapvpwrvgnd_1
XFILLER_20_118 VGND VGND VPWR VPWR sky130_fd_sc_hd__fill_2
X_0863_ net54 net53 net52 VGND VGND VPWR VPWR _0216_ sky130_fd_sc_hd__and3_1
X_0794_ _0151_ _0155_ _0157_ _0158_ VGND VGND VPWR VPWR _0161_ sky130_fd_sc_hd__a22oi_1
XPHY_EDGE_ROW_21_Left_74 VGND VGND VPWR VPWR sky130_fd_sc_hd__decap_3
X_1346_ _0649_ _0655_ _0668_ VGND VGND VPWR VPWR _0670_ sky130_fd_sc_hd__nand3_1
X_1415_ clknet_3_0__leaf_clk _0041_ VGND VGND VPWR VPWR net27 sky130_fd_sc_hd__dfxtp_1
XFILLER_3_93 VPWR VGND VPWR VGND sky130_ef_sc_hd__decap_12
XFILLER_51_254 VGND VGND VPWR VPWR sky130_fd_sc_hd__fill_1
XFILLER_51_221 VGND VGND VPWR VPWR sky130_fd_sc_hd__decap_3
X_1277_ _0567_ _0569_ _0601_ _0086_ VGND VGND VPWR VPWR _0604_ sky130_fd_sc_hd__a31o_1
XFILLER_36_251 VGND VGND VPWR VPWR sky130_fd_sc_hd__fill_1
Xfanout131 net10 VGND VGND VPWR VPWR net131 sky130_fd_sc_hd__clkbuf_2
Xfanout120 net14 VGND VGND VPWR VPWR net120 sky130_fd_sc_hd__buf_2
XFILLER_47_55 VGND VGND VPWR VPWR sky130_fd_sc_hd__fill_1
XTAP_TAPCELL_ROW_6_144 VGND VPWR sky130_fd_sc_hd__tapvpwrvgnd_1
XFILLER_8_27 VGND VGND VPWR VPWR sky130_fd_sc_hd__fill_1
XFILLER_27_284 VGND VGND VPWR VPWR sky130_fd_sc_hd__fill_1
XFILLER_6_177 VPWR VGND VPWR VGND sky130_ef_sc_hd__decap_12
XFILLER_6_133 VGND VGND VPWR VPWR sky130_fd_sc_hd__decap_6
XFILLER_10_195 VGND VGND VPWR VPWR sky130_fd_sc_hd__fill_1
XTAP_TAPCELL_ROW_12_179 VGND VPWR sky130_fd_sc_hd__tapvpwrvgnd_1
X_1200_ net125 net121 net96 net99 VGND VGND VPWR VPWR _0528_ sky130_fd_sc_hd__and4_1
X_1131_ net128 net176 net93 net130 VGND VGND VPWR VPWR _0460_ sky130_fd_sc_hd__a22o_4
X_1062_ _0388_ _0389_ VGND VGND VPWR VPWR _0392_ sky130_fd_sc_hd__nor2_2
X_0915_ net105 net91 net133 net109 VGND VGND VPWR VPWR _0249_ sky130_fd_sc_hd__a22o_1
X_0846_ net71 _0204_ VGND VGND VPWR VPWR _0205_ sky130_fd_sc_hd__nand2_4
X_0777_ product_reg\[9\] net68 VGND VGND VPWR VPWR _0146_ sky130_fd_sc_hd__or2_1
XFILLER_0_309 VGND VGND VPWR VPWR sky130_fd_sc_hd__fill_2
X_1329_ _0598_ _0624_ _0625_ VGND VGND VPWR VPWR _0654_ sky130_fd_sc_hd__o21ai_2
XFILLER_33_57 VGND VGND VPWR VPWR sky130_fd_sc_hd__fill_1
XFILLER_33_35 VGND VGND VPWR VPWR sky130_fd_sc_hd__decap_3
XFILLER_24_221 VGND VGND VPWR VPWR sky130_fd_sc_hd__decap_8
XFILLER_3_125 VPWR VGND VPWR VGND sky130_ef_sc_hd__decap_12
XFILLER_3_169 VPWR VGND VPWR VGND sky130_ef_sc_hd__decap_12
XTAP_TAPCELL_ROW_17_205 VGND VPWR sky130_fd_sc_hd__tapvpwrvgnd_1
X_0700_ net93 VGND VGND VPWR VPWR _0080_ sky130_fd_sc_hd__inv_2
XFILLER_30_224 VGND VGND VPWR VPWR sky130_fd_sc_hd__fill_1
XTAP_TAPCELL_ROW_0_106 VGND VPWR sky130_fd_sc_hd__tapvpwrvgnd_1
XFILLER_24_3 VGND VGND VPWR VPWR sky130_fd_sc_hd__fill_1
X_1114_ _0436_ _0441_ _0440_ VGND VGND VPWR VPWR _0444_ sky130_fd_sc_hd__o21a_1
X_1045_ _0360_ _0373_ _0372_ _0323_ VGND VGND VPWR VPWR _0376_ sky130_fd_sc_hd__o211ai_2
X_0829_ _0189_ _0190_ _0191_ net83 VGND VGND VPWR VPWR _0016_ sky130_fd_sc_hd__o211a_1
XTAP_TAPCELL_ROW_31_285 VGND VPWR sky130_fd_sc_hd__tapvpwrvgnd_1
XFILLER_21_279 VGND VGND VPWR VPWR sky130_fd_sc_hd__fill_1
XTAP_TAPCELL_ROW_39_330 VGND VPWR sky130_fd_sc_hd__tapvpwrvgnd_1
XFILLER_5_39 VPWR VGND VPWR VGND sky130_ef_sc_hd__decap_12
XFILLER_7_261 VPWR VGND VPWR VGND sky130_ef_sc_hd__decap_12
XPHY_EDGE_ROW_7_Right_7 VGND VGND VPWR VPWR sky130_fd_sc_hd__decap_3
XFILLER_38_154 VPWR VGND VPWR VGND sky130_ef_sc_hd__decap_12
XTAP_TAPCELL_ROW_36_311 VGND VPWR sky130_fd_sc_hd__tapvpwrvgnd_1
XFILLER_14_15 VPWR VGND VPWR VGND sky130_ef_sc_hd__decap_12
X_1028_ _0351_ _0356_ _0352_ VGND VGND VPWR VPWR _0359_ sky130_fd_sc_hd__nand3_2
XFILLER_30_25 VGND VGND VPWR VPWR sky130_fd_sc_hd__decap_3
XFILLER_17_305 VGND VGND VPWR VPWR sky130_fd_sc_hd__decap_6
XTAP_TAPCELL_ROW_50_391 VGND VPWR sky130_fd_sc_hd__tapvpwrvgnd_1
XTAP_TAPCELL_ROW_42_347 VGND VPWR sky130_fd_sc_hd__tapvpwrvgnd_1
XFILLER_4_253 VPWR VGND VPWR VGND sky130_ef_sc_hd__decap_12
XFILLER_35_113 VPWR VGND VPWR VGND sky130_ef_sc_hd__decap_12
XFILLER_50_138 VGND VGND VPWR VPWR sky130_fd_sc_hd__fill_2
Xrebuffer65 _0498_ VGND VGND VPWR VPWR net200 sky130_fd_sc_hd__buf_4
Xrebuffer21 net155 VGND VGND VPWR VPWR net156 sky130_fd_sc_hd__dlygate4sd1_1
Xrebuffer10 _0407_ VGND VGND VPWR VPWR net145 sky130_fd_sc_hd__buf_2
Xrebuffer32 _0455_ VGND VGND VPWR VPWR net167 sky130_fd_sc_hd__buf_4
Xrebuffer43 _0476_ VGND VGND VPWR VPWR net178 sky130_fd_sc_hd__buf_1
Xrebuffer54 _0479_ VGND VGND VPWR VPWR net189 sky130_fd_sc_hd__clkbuf_1
XFILLER_41_57 VPWR VGND VPWR VGND sky130_ef_sc_hd__decap_12
XFILLER_41_46 VGND VGND VPWR VPWR sky130_fd_sc_hd__decap_8
XFILLER_1_223 VGND VGND VPWR VPWR sky130_fd_sc_hd__fill_1
XFILLER_2_29 VPWR VGND VPWR VGND sky130_ef_sc_hd__decap_12
XFILLER_32_138 VGND VGND VPWR VPWR sky130_fd_sc_hd__fill_2
XFILLER_32_105 VGND VGND VPWR VPWR sky130_fd_sc_hd__decap_3
X_1431_ clknet_3_3__leaf_clk _0057_ VGND VGND VPWR VPWR product_reg\[14\] sky130_fd_sc_hd__dfxtp_1
X_1362_ _0067_ net17 net18 net80 _0684_ VGND VGND VPWR VPWR _0057_ sky130_fd_sc_hd__o41ai_1
X_1293_ _0572_ net114 net104 VGND VGND VPWR VPWR _0619_ sky130_fd_sc_hd__and3_1
XFILLER_23_105 VGND VGND VPWR VPWR sky130_fd_sc_hd__fill_1
XFILLER_36_68 VGND VGND VPWR VPWR sky130_fd_sc_hd__decap_4
XFILLER_14_105 VGND VGND VPWR VPWR sky130_fd_sc_hd__fill_1
XTAP_TAPCELL_ROW_9_164 VGND VPWR sky130_fd_sc_hd__tapvpwrvgnd_1
XFILLER_45_274 VGND VGND VPWR VPWR sky130_fd_sc_hd__decap_6
X_0862_ net371 net52 net53 _0210_ net411 VGND VGND VPWR VPWR _0215_ sky130_fd_sc_hd__a41o_1
XFILLER_9_153 VPWR VGND VPWR VGND sky130_ef_sc_hd__decap_12
X_0931_ net109 net129 VGND VGND VPWR VPWR _0264_ sky130_fd_sc_hd__nand2_2
XFILLER_20_108 VGND VGND VPWR VPWR sky130_fd_sc_hd__fill_1
X_0793_ _0151_ _0155_ _0157_ _0158_ VGND VGND VPWR VPWR _0160_ sky130_fd_sc_hd__and4_1
Xrebuffer1 _0381_ VGND VGND VPWR VPWR net136 sky130_fd_sc_hd__dlygate4sd1_1
X_1345_ _0649_ _0655_ _0665_ _0667_ VGND VGND VPWR VPWR _0669_ sky130_fd_sc_hd__o2bb2ai_1
X_1276_ _0567_ _0569_ _0601_ VGND VGND VPWR VPWR _0603_ sky130_fd_sc_hd__a21o_1
X_1414_ clknet_3_0__leaf_clk _0040_ VGND VGND VPWR VPWR net26 sky130_fd_sc_hd__dfxtp_1
XFILLER_28_219 VGND VGND VPWR VPWR sky130_fd_sc_hd__fill_1
XFILLER_11_108 VGND VGND VPWR VPWR sky130_fd_sc_hd__decap_4
XFILLER_22_48 VGND VGND VPWR VPWR sky130_fd_sc_hd__fill_2
XTAP_TAPCELL_ROW_6_145 VGND VPWR sky130_fd_sc_hd__tapvpwrvgnd_1
Xfanout132 net133 VGND VGND VPWR VPWR net132 sky130_fd_sc_hd__clkbuf_4
Xfanout110 net113 VGND VGND VPWR VPWR net110 sky130_fd_sc_hd__clkbuf_4
Xfanout121 net122 VGND VGND VPWR VPWR net121 sky130_fd_sc_hd__buf_12
XFILLER_10_141 VGND VGND VPWR VPWR sky130_fd_sc_hd__decap_3
XFILLER_6_189 VGND VGND VPWR VPWR sky130_fd_sc_hd__decap_6
X_1130_ net128 net177 net93 net130 VGND VGND VPWR VPWR _0459_ sky130_fd_sc_hd__a22oi_2
X_1061_ _0384_ _0387_ net134 net115 VGND VGND VPWR VPWR _0391_ sky130_fd_sc_hd__o211a_1
X_0845_ net47 net46 net45 net44 VGND VGND VPWR VPWR _0204_ sky130_fd_sc_hd__and4_1
X_0914_ net105 net90 net132 net109 VGND VGND VPWR VPWR _0248_ sky130_fd_sc_hd__a22oi_1
X_0776_ product_reg\[9\] net68 VGND VGND VPWR VPWR _0145_ sky130_fd_sc_hd__nand2_1
X_1328_ _0566_ _0515_ _0652_ VGND VGND VPWR VPWR _0653_ sky130_fd_sc_hd__o21ai_4
X_1259_ _0463_ _0535_ _0580_ _0581_ VGND VGND VPWR VPWR _0586_ sky130_fd_sc_hd__o2bb2ai_4
XPHY_EDGE_ROW_49_Left_102 VGND VGND VPWR VPWR sky130_fd_sc_hd__decap_3
XFILLER_3_137 VPWR VGND VPWR VGND sky130_ef_sc_hd__decap_12
XFILLER_15_255 VPWR VGND VPWR VGND sky130_ef_sc_hd__decap_12
XTAP_TAPCELL_ROW_17_206 VGND VPWR sky130_fd_sc_hd__tapvpwrvgnd_1
XTAP_TAPCELL_ROW_25_250 VGND VPWR sky130_fd_sc_hd__tapvpwrvgnd_1
XTAP_TAPCELL_ROW_48_375 VGND VPWR sky130_fd_sc_hd__tapvpwrvgnd_1
X_1113_ _0366_ _0437_ _0438_ VGND VGND VPWR VPWR _0443_ sky130_fd_sc_hd__nand3b_1
XTAP_TAPCELL_ROW_0_107 VGND VPWR sky130_fd_sc_hd__tapvpwrvgnd_1
XFILLER_0_62 VPWR VGND VPWR VGND sky130_ef_sc_hd__decap_12
X_1044_ _0360_ _0373_ _0372_ _0323_ VGND VGND VPWR VPWR _0375_ sky130_fd_sc_hd__o211a_1
X_0828_ net79 net43 VGND VGND VPWR VPWR _0191_ sky130_fd_sc_hd__or2_1
X_0759_ net78 net414 net85 _0130_ VGND VGND VPWR VPWR _0007_ sky130_fd_sc_hd__o211a_1
XTAP_TAPCELL_ROW_31_286 VGND VPWR sky130_fd_sc_hd__tapvpwrvgnd_1
XFILLER_47_177 VGND VGND VPWR VPWR sky130_fd_sc_hd__decap_8
XFILLER_50_309 VGND VGND VPWR VPWR sky130_fd_sc_hd__fill_2
XFILLER_7_273 VGND VGND VPWR VPWR sky130_fd_sc_hd__decap_6
XFILLER_38_166 VGND VGND VPWR VPWR sky130_fd_sc_hd__decap_8
XTAP_TAPCELL_ROW_36_312 VGND VPWR sky130_fd_sc_hd__tapvpwrvgnd_1
Xclkbuf_3_5__f_clk clknet_0_clk VGND VGND VPWR VPWR clknet_3_5__leaf_clk sky130_fd_sc_hd__clkbuf_16
X_1027_ _0353_ _0355_ _0357_ VGND VGND VPWR VPWR _0358_ sky130_fd_sc_hd__a21oi_1
XFILLER_14_27 VGND VGND VPWR VPWR sky130_fd_sc_hd__fill_1
XFILLER_39_57 VGND VGND VPWR VPWR sky130_fd_sc_hd__decap_8
XFILLER_44_136 VGND VGND VPWR VPWR sky130_fd_sc_hd__decap_4
XFILLER_32_309 VGND VGND VPWR VPWR sky130_fd_sc_hd__fill_2
XFILLER_4_221 VPWR VGND VPWR VGND sky130_ef_sc_hd__decap_12
XFILLER_4_265 VPWR VGND VPWR VGND sky130_ef_sc_hd__decap_12
XFILLER_35_125 VGND VGND VPWR VPWR sky130_fd_sc_hd__fill_1
XFILLER_6_83 VGND VGND VPWR VPWR sky130_fd_sc_hd__fill_1
Xrebuffer11 net173 VGND VGND VPWR VPWR net146 sky130_fd_sc_hd__dlymetal6s2s_1
Xrebuffer44 _0602_ VGND VGND VPWR VPWR net179 sky130_fd_sc_hd__clkbuf_2
Xrebuffer55 _0554_ VGND VGND VPWR VPWR net190 sky130_fd_sc_hd__buf_1
XFILLER_14_309 VGND VGND VPWR VPWR sky130_fd_sc_hd__fill_2
Xrebuffer66 _0470_ VGND VGND VPWR VPWR net201 sky130_fd_sc_hd__buf_2
Xrebuffer22 net184 VGND VGND VPWR VPWR net157 sky130_fd_sc_hd__buf_2
Xrebuffer33 _0427_ VGND VGND VPWR VPWR net168 sky130_fd_sc_hd__dlymetal6s2s_1
XFILLER_41_69 VPWR VGND VPWR VGND sky130_ef_sc_hd__decap_12
XFILLER_1_279 VGND VGND VPWR VPWR sky130_fd_sc_hd__fill_1
XFILLER_17_136 VGND VGND VPWR VPWR sky130_fd_sc_hd__decap_8
X_1430_ clknet_3_2__leaf_clk _0056_ VGND VGND VPWR VPWR product_reg\[13\] sky130_fd_sc_hd__dfxtp_1
X_1361_ _0681_ _0676_ _0000_ _0682_ VGND VGND VPWR VPWR _0684_ sky130_fd_sc_hd__o211ai_2
X_1292_ _0613_ _0615_ _0586_ _0588_ VGND VGND VPWR VPWR _0618_ sky130_fd_sc_hd__o211ai_2
XFILLER_31_161 VGND VGND VPWR VPWR sky130_fd_sc_hd__decap_6
XFILLER_36_36 VGND VGND VPWR VPWR sky130_fd_sc_hd__decap_3
XFILLER_52_57 VGND VGND VPWR VPWR sky130_fd_sc_hd__fill_2
XTAP_TAPCELL_ROW_9_165 VGND VPWR sky130_fd_sc_hd__tapvpwrvgnd_1
XFILLER_45_264 VGND VGND VPWR VPWR sky130_fd_sc_hd__decap_4
XFILLER_26_80 VGND VGND VPWR VPWR sky130_fd_sc_hd__fill_1
X_0861_ _0214_ _0213_ net87 VGND VGND VPWR VPWR _0025_ sky130_fd_sc_hd__and3_1
X_0792_ _0155_ _0151_ _0158_ VGND VGND VPWR VPWR _0159_ sky130_fd_sc_hd__nand3_4
XFILLER_9_165 VGND VGND VPWR VPWR sky130_fd_sc_hd__decap_3
X_0930_ _0246_ _0248_ _0247_ VGND VGND VPWR VPWR _0263_ sky130_fd_sc_hd__o21a_1
Xrebuffer2 net178 VGND VGND VPWR VPWR net137 sky130_fd_sc_hd__dlymetal6s2s_1
XFILLER_47_3 VPWR VGND VPWR VGND sky130_ef_sc_hd__decap_12
X_1413_ clknet_3_0__leaf_clk _0039_ VGND VGND VPWR VPWR net25 sky130_fd_sc_hd__dfxtp_1
X_1344_ _0665_ _0667_ VGND VGND VPWR VPWR _0668_ sky130_fd_sc_hd__nor2_1
X_1275_ _0569_ _0567_ _0601_ VGND VGND VPWR VPWR _0602_ sky130_fd_sc_hd__a21oi_4
XFILLER_3_51 VGND VGND VPWR VPWR sky130_fd_sc_hd__decap_4
XFILLER_36_286 VGND VGND VPWR VPWR sky130_fd_sc_hd__fill_2
Xfanout133 net10 VGND VGND VPWR VPWR net133 sky130_fd_sc_hd__buf_4
XTAP_TAPCELL_ROW_6_146 VGND VPWR sky130_fd_sc_hd__tapvpwrvgnd_1
Xfanout111 net113 VGND VGND VPWR VPWR net111 sky130_fd_sc_hd__buf_2
Xfanout122 net124 VGND VGND VPWR VPWR net122 sky130_fd_sc_hd__buf_12
Xfanout100 net6 VGND VGND VPWR VPWR net100 sky130_fd_sc_hd__buf_8
XFILLER_47_57 VPWR VGND VPWR VGND sky130_ef_sc_hd__decap_12
XFILLER_27_220 VGND VGND VPWR VPWR sky130_fd_sc_hd__decap_4
XPHY_EDGE_ROW_29_Right_29 VGND VGND VPWR VPWR sky130_fd_sc_hd__decap_3
XPHY_EDGE_ROW_38_Right_38 VGND VGND VPWR VPWR sky130_fd_sc_hd__decap_3
XFILLER_8_29 VPWR VGND VPWR VGND sky130_ef_sc_hd__decap_12
XPHY_EDGE_ROW_47_Right_47 VGND VGND VPWR VPWR sky130_fd_sc_hd__decap_3
X_1060_ _0075_ net89 _0385_ _0386_ VGND VGND VPWR VPWR _0390_ sky130_fd_sc_hd__o211a_1
XTAP_TAPCELL_ROW_28_270 VGND VPWR sky130_fd_sc_hd__tapvpwrvgnd_1
X_0844_ net71 net45 net44 net46 net415 VGND VGND VPWR VPWR _0203_ sky130_fd_sc_hd__a41o_1
X_0775_ net79 net409 _0142_ _0143_ net87 VGND VGND VPWR VPWR _0009_ sky130_fd_sc_hd__o221a_1
X_0913_ net105 net91 net132 net108 VGND VGND VPWR VPWR _0247_ sky130_fd_sc_hd__nand4_4
X_1189_ net388 _0232_ _0517_ _0516_ VGND VGND VPWR VPWR _0051_ sky130_fd_sc_hd__a22o_1
X_1327_ _0559_ _0568_ _0651_ VGND VGND VPWR VPWR _0652_ sky130_fd_sc_hd__a21oi_4
X_1258_ _0329_ _0461_ _0535_ _0584_ VGND VGND VPWR VPWR _0585_ sky130_fd_sc_hd__o211ai_4
XFILLER_3_149 VPWR VGND VPWR VGND sky130_ef_sc_hd__decap_12
XFILLER_3_105 VGND VGND VPWR VPWR sky130_fd_sc_hd__decap_6
XFILLER_15_267 VPWR VGND VPWR VGND sky130_ef_sc_hd__decap_12
XTAP_TAPCELL_ROW_17_207 VGND VPWR sky130_fd_sc_hd__tapvpwrvgnd_1
XTAP_TAPCELL_ROW_25_251 VGND VPWR sky130_fd_sc_hd__tapvpwrvgnd_1
XTAP_TAPCELL_ROW_48_376 VGND VPWR sky130_fd_sc_hd__tapvpwrvgnd_1
XFILLER_0_41 VGND VGND VPWR VPWR sky130_fd_sc_hd__decap_4
XFILLER_0_74 VGND VGND VPWR VPWR sky130_fd_sc_hd__decap_8
XFILLER_0_85 VPWR VGND VPWR VGND sky130_ef_sc_hd__decap_12
XTAP_TAPCELL_ROW_0_108 VGND VPWR sky130_fd_sc_hd__tapvpwrvgnd_1
X_1043_ _0315_ _0318_ _0370_ _0371_ VGND VGND VPWR VPWR _0374_ sky130_fd_sc_hd__nand4_4
X_1112_ _0362_ _0437_ _0438_ _0364_ VGND VGND VPWR VPWR _0442_ sky130_fd_sc_hd__and4b_1
X_0827_ _0185_ _0180_ _0187_ _0188_ _0070_ VGND VGND VPWR VPWR _0190_ sky130_fd_sc_hd__a41o_1
X_0758_ _0127_ _0128_ net78 VGND VGND VPWR VPWR _0130_ sky130_fd_sc_hd__o21ai_1
X_0689_ product_reg\[5\] VGND VGND VPWR VPWR _0069_ sky130_fd_sc_hd__inv_2
XFILLER_28_26 VGND VGND VPWR VPWR sky130_fd_sc_hd__fill_2
XFILLER_20_281 VGND VGND VPWR VPWR sky130_fd_sc_hd__decap_8
XTAP_TAPCELL_ROW_22_232 VGND VPWR sky130_fd_sc_hd__tapvpwrvgnd_1
XFILLER_47_134 VGND VGND VPWR VPWR sky130_fd_sc_hd__fill_2
XFILLER_11_281 VPWR VGND VPWR VGND sky130_ef_sc_hd__decap_12
XTAP_TAPCELL_ROW_36_313 VGND VPWR sky130_fd_sc_hd__tapvpwrvgnd_1
X_1026_ _0295_ _0307_ _0309_ VGND VGND VPWR VPWR _0357_ sky130_fd_sc_hd__o21ai_4
XFILLER_30_49 VGND VGND VPWR VPWR sky130_fd_sc_hd__fill_1
XFILLER_29_134 VGND VGND VPWR VPWR sky130_fd_sc_hd__decap_6
XFILLER_29_167 VGND VGND VPWR VPWR sky130_fd_sc_hd__fill_1
XFILLER_4_233 VPWR VGND VPWR VGND sky130_ef_sc_hd__decap_12
XFILLER_20_60 VGND VGND VPWR VPWR sky130_fd_sc_hd__fill_2
XFILLER_4_277 VPWR VGND VPWR VGND sky130_ef_sc_hd__decap_12
XFILLER_35_137 VGND VGND VPWR VPWR sky130_fd_sc_hd__decap_4
Xrebuffer34 _0327_ VGND VGND VPWR VPWR net169 sky130_fd_sc_hd__buf_6
Xrebuffer23 _0406_ VGND VGND VPWR VPWR net158 sky130_fd_sc_hd__dlymetal6s2s_1
Xrebuffer45 _0470_ VGND VGND VPWR VPWR net180 sky130_fd_sc_hd__buf_6
Xrebuffer12 net186 VGND VGND VPWR VPWR net147 sky130_fd_sc_hd__dlymetal6s2s_1
Xrebuffer56 net141 VGND VGND VPWR VPWR net191 sky130_fd_sc_hd__buf_6
X_1009_ net110 net119 VGND VGND VPWR VPWR _0340_ sky130_fd_sc_hd__nand2_1
XFILLER_1_225 VPWR VGND VPWR VGND sky130_ef_sc_hd__decap_12
Xoutput70 net70 VGND VGND VPWR VPWR v_b_out sky130_fd_sc_hd__buf_2
X_1360_ _0674_ _0673_ _0680_ _0679_ VGND VGND VPWR VPWR _0683_ sky130_fd_sc_hd__o2bb2ai_1
X_1291_ _0613_ _0615_ _0586_ _0588_ VGND VGND VPWR VPWR _0617_ sky130_fd_sc_hd__o211a_1
XTAP_TAPCELL_ROW_52_400 VGND VPWR sky130_fd_sc_hd__tapvpwrvgnd_1
XFILLER_36_26 VGND VGND VPWR VPWR sky130_fd_sc_hd__fill_2
XFILLER_22_184 VGND VGND VPWR VPWR sky130_fd_sc_hd__decap_4
XFILLER_7_3 VPWR VGND VPWR VGND sky130_ef_sc_hd__decap_12
XFILLER_13_140 VPWR VGND VPWR VGND sky130_ef_sc_hd__decap_12
X_0860_ net53 net52 net371 net76 VGND VGND VPWR VPWR _0214_ sky130_fd_sc_hd__nand4_4
X_0791_ product_reg\[11\] net39 VGND VGND VPWR VPWR _0158_ sky130_fd_sc_hd__nand2_1
XFILLER_42_91 VGND VGND VPWR VPWR sky130_fd_sc_hd__fill_1
Xrebuffer3 _0476_ VGND VGND VPWR VPWR net138 sky130_fd_sc_hd__dlymetal6s2s_1
X_1343_ _0666_ VGND VGND VPWR VPWR _0667_ sky130_fd_sc_hd__inv_2
X_1412_ clknet_3_0__leaf_clk _0038_ VGND VGND VPWR VPWR net24 sky130_fd_sc_hd__dfxtp_1
X_1274_ _0598_ _0599_ VGND VGND VPWR VPWR _0601_ sky130_fd_sc_hd__or2_1
XTAP_TAPCELL_ROW_14_190 VGND VPWR sky130_fd_sc_hd__tapvpwrvgnd_1
X_0989_ _0281_ _0284_ _0319_ VGND VGND VPWR VPWR _0321_ sky130_fd_sc_hd__a21o_1
XTAP_TAPCELL_ROW_6_147 VGND VPWR sky130_fd_sc_hd__tapvpwrvgnd_1
Xfanout123 net192 VGND VGND VPWR VPWR net123 sky130_fd_sc_hd__buf_6
Xfanout101 net6 VGND VGND VPWR VPWR net101 sky130_fd_sc_hd__buf_2
Xfanout112 net113 VGND VGND VPWR VPWR net112 sky130_fd_sc_hd__clkbuf_2
Xfanout134 net1 VGND VGND VPWR VPWR net134 sky130_fd_sc_hd__buf_2
XFILLER_10_121 VGND VGND VPWR VPWR sky130_fd_sc_hd__fill_1
XPHY_EDGE_ROW_25_Left_78 VGND VGND VPWR VPWR sky130_fd_sc_hd__decap_3
X_0912_ net129 net111 VGND VGND VPWR VPWR _0246_ sky130_fd_sc_hd__nand2_1
X_0843_ _0201_ _0202_ net86 VGND VGND VPWR VPWR _0019_ sky130_fd_sc_hd__and3_1
X_0774_ product_reg\[7\] net66 _0138_ _0141_ _0139_ VGND VGND VPWR VPWR _0144_ sky130_fd_sc_hd__o2111ai_4
X_1326_ _0600_ _0624_ _0625_ VGND VGND VPWR VPWR _0651_ sky130_fd_sc_hd__o21ai_1
XTAP_TAPCELL_ROW_3_128 VGND VPWR sky130_fd_sc_hd__tapvpwrvgnd_1
X_1188_ _0512_ _0515_ net87 net80 VGND VGND VPWR VPWR _0517_ sky130_fd_sc_hd__o211a_1
X_1257_ _0582_ _0583_ VGND VGND VPWR VPWR _0584_ sky130_fd_sc_hd__nand2_1
XFILLER_47_305 VGND VGND VPWR VPWR sky130_fd_sc_hd__fill_2
XTAP_TAPCELL_ROW_17_208 VGND VPWR sky130_fd_sc_hd__tapvpwrvgnd_1
XFILLER_15_279 VGND VGND VPWR VPWR sky130_fd_sc_hd__fill_1
XTAP_TAPCELL_ROW_25_252 VGND VPWR sky130_fd_sc_hd__tapvpwrvgnd_1
XTAP_TAPCELL_ROW_48_377 VGND VPWR sky130_fd_sc_hd__tapvpwrvgnd_1
XFILLER_0_97 VPWR VGND VPWR VGND sky130_ef_sc_hd__decap_12
XTAP_TAPCELL_ROW_0_109 VGND VPWR sky130_fd_sc_hd__tapvpwrvgnd_1
X_1042_ _0351_ _0356_ _0352_ _0369_ VGND VGND VPWR VPWR _0373_ sky130_fd_sc_hd__a31o_1
X_1111_ _0438_ _0364_ net117 net134 VGND VGND VPWR VPWR _0441_ sky130_fd_sc_hd__nand4_1
X_0826_ _0180_ _0185_ _0187_ _0188_ VGND VGND VPWR VPWR _0189_ sky130_fd_sc_hd__a22oi_1
X_0757_ product_reg\[5\] net64 _0126_ _0125_ VGND VGND VPWR VPWR _0129_ sky130_fd_sc_hd__o211ai_2
X_0688_ product_reg\[7\] VGND VGND VPWR VPWR _0068_ sky130_fd_sc_hd__inv_2
XFILLER_0_109 VGND VGND VPWR VPWR sky130_fd_sc_hd__decap_3
X_1309_ _0611_ _0633_ VGND VGND VPWR VPWR _0634_ sky130_fd_sc_hd__nand2_1
XFILLER_44_15 VPWR VGND VPWR VGND sky130_ef_sc_hd__decap_12
XFILLER_8_209 VPWR VGND VPWR VGND sky130_ef_sc_hd__decap_12
XTAP_TAPCELL_ROW_22_233 VGND VPWR sky130_fd_sc_hd__tapvpwrvgnd_1
XFILLER_20_260 VGND VGND VPWR VPWR sky130_fd_sc_hd__decap_4
XFILLER_18_60 VGND VGND VPWR VPWR sky130_fd_sc_hd__decap_3
XFILLER_11_293 VPWR VGND VPWR VGND sky130_ef_sc_hd__decap_12
XFILLER_22_3 VGND VGND VPWR VPWR sky130_fd_sc_hd__fill_1
XTAP_TAPCELL_ROW_36_314 VGND VPWR sky130_fd_sc_hd__tapvpwrvgnd_1
XFILLER_14_29 VGND VGND VPWR VPWR sky130_fd_sc_hd__decap_6
X_1025_ _0295_ _0307_ _0309_ VGND VGND VPWR VPWR _0356_ sky130_fd_sc_hd__o21a_4
XPHY_EDGE_ROW_28_Left_81 VGND VGND VPWR VPWR sky130_fd_sc_hd__decap_3
X_0809_ product_reg\[13\] net41 VGND VGND VPWR VPWR _0174_ sky130_fd_sc_hd__and2_1
XPHY_EDGE_ROW_12_Left_65 VGND VGND VPWR VPWR sky130_fd_sc_hd__decap_3
XFILLER_44_127 VGND VGND VPWR VPWR sky130_fd_sc_hd__decap_4
XFILLER_29_179 VGND VGND VPWR VPWR sky130_fd_sc_hd__decap_4
XFILLER_4_289 VPWR VGND VPWR VGND sky130_ef_sc_hd__decap_12
XFILLER_4_245 VGND VGND VPWR VPWR sky130_fd_sc_hd__decap_6
XFILLER_29_92 VGND VGND VPWR VPWR sky130_fd_sc_hd__decap_3
XFILLER_45_91 VGND VGND VPWR VPWR sky130_fd_sc_hd__fill_1
XFILLER_45_80 VGND VGND VPWR VPWR sky130_fd_sc_hd__fill_1
XFILLER_43_193 VGND VGND VPWR VPWR sky130_fd_sc_hd__decap_4
XFILLER_43_160 VGND VGND VPWR VPWR sky130_fd_sc_hd__fill_1
XANTENNA_1 net88 VGND VGND VPWR VPWR sky130_fd_sc_hd__diode_2
XFILLER_6_41 VPWR VGND VPWR VGND sky130_ef_sc_hd__decap_12
XFILLER_6_85 VPWR VGND VPWR VGND sky130_ef_sc_hd__decap_12
Xrebuffer35 net169 VGND VGND VPWR VPWR net170 sky130_fd_sc_hd__dlymetal6s2s_1
Xrebuffer46 _0405_ VGND VGND VPWR VPWR net181 sky130_fd_sc_hd__clkbuf_2
Xrebuffer13 _0477_ VGND VGND VPWR VPWR net148 sky130_fd_sc_hd__clkbuf_2
Xrebuffer57 net124 VGND VGND VPWR VPWR net192 sky130_fd_sc_hd__buf_2
Xrebuffer24 _0437_ VGND VGND VPWR VPWR net159 sky130_fd_sc_hd__dlymetal6s2s_1
X_1008_ net170 _0335_ _0302_ _0324_ _0334_ VGND VGND VPWR VPWR _0339_ sky130_fd_sc_hd__o221ai_4
Xrebuffer125 _0453_ VGND VGND VPWR VPWR net260 sky130_fd_sc_hd__dlygate4sd1_1
XFILLER_1_237 VPWR VGND VPWR VGND sky130_ef_sc_hd__decap_12
XFILLER_17_127 VGND VGND VPWR VPWR sky130_fd_sc_hd__fill_1
XFILLER_40_141 VPWR VGND VPWR VGND sky130_ef_sc_hd__decap_12
Xoutput60 net60 VGND VGND VPWR VPWR psum[30] sky130_fd_sc_hd__buf_2
XFILLER_0_281 VPWR VGND VPWR VGND sky130_ef_sc_hd__decap_12
X_1290_ _0614_ _0609_ _0587_ _0586_ _0613_ VGND VGND VPWR VPWR _0616_ sky130_fd_sc_hd__a221oi_4
XTAP_TAPCELL_ROW_52_401 VGND VPWR sky130_fd_sc_hd__tapvpwrvgnd_1
XFILLER_52_15 VPWR VGND VPWR VGND sky130_ef_sc_hd__decap_12
XFILLER_6_307 VGND VGND VPWR VPWR sky130_fd_sc_hd__fill_1
XFILLER_22_141 VGND VGND VPWR VPWR sky130_fd_sc_hd__decap_4
XFILLER_45_200 VPWR VGND VPWR VGND sky130_ef_sc_hd__decap_12
X_0790_ product_reg\[11\] net39 VGND VGND VPWR VPWR _0157_ sky130_fd_sc_hd__or2_1
XFILLER_42_70 VPWR VGND VPWR VGND sky130_ef_sc_hd__decap_12
Xrebuffer4 _0427_ VGND VGND VPWR VPWR net139 sky130_fd_sc_hd__dlymetal6s2s_1
X_1342_ _0615_ _0638_ _0639_ _0644_ _0664_ VGND VGND VPWR VPWR _0666_ sky130_fd_sc_hd__a311o_1
X_1273_ _0551_ net190 _0596_ _0597_ VGND VGND VPWR VPWR _0600_ sky130_fd_sc_hd__o211ai_1
X_1411_ clknet_3_5__leaf_clk _0037_ VGND VGND VPWR VPWR net23 sky130_fd_sc_hd__dfxtp_1
XFILLER_36_233 VGND VGND VPWR VPWR sky130_fd_sc_hd__decap_3
XTAP_TAPCELL_ROW_14_191 VGND VPWR sky130_fd_sc_hd__tapvpwrvgnd_1
X_0988_ _0284_ _0281_ _0319_ VGND VGND VPWR VPWR _0320_ sky130_fd_sc_hd__a21oi_4
Xfanout102 net103 VGND VGND VPWR VPWR net102 sky130_fd_sc_hd__buf_8
Xfanout113 net2 VGND VGND VPWR VPWR net113 sky130_fd_sc_hd__clkbuf_2
XFILLER_47_15 VPWR VGND VPWR VGND sky130_ef_sc_hd__decap_12
XTAP_TAPCELL_ROW_6_148 VGND VPWR sky130_fd_sc_hd__tapvpwrvgnd_1
Xfanout135 net1 VGND VGND VPWR VPWR net135 sky130_fd_sc_hd__clkbuf_2
Xfanout124 net13 VGND VGND VPWR VPWR net124 sky130_fd_sc_hd__buf_6
XFILLER_50_291 VGND VGND VPWR VPWR sky130_fd_sc_hd__fill_1
XPHY_EDGE_ROW_0_Left_53 VGND VGND VPWR VPWR sky130_fd_sc_hd__decap_3
XFILLER_33_236 VGND VGND VPWR VPWR sky130_fd_sc_hd__decap_4
XFILLER_33_225 VGND VGND VPWR VPWR sky130_fd_sc_hd__decap_6
X_0842_ net46 net45 net44 net72 VGND VGND VPWR VPWR _0202_ sky130_fd_sc_hd__nand4_1
X_0911_ net135 net126 VGND VGND VPWR VPWR _0245_ sky130_fd_sc_hd__nand2_1
XFILLER_52_3 VPWR VGND VPWR VGND sky130_ef_sc_hd__decap_12
X_0773_ _0132_ _0140_ _0141_ _0070_ VGND VGND VPWR VPWR _0143_ sky130_fd_sc_hd__a31o_1
XFILLER_5_181 VPWR VGND VPWR VGND sky130_ef_sc_hd__decap_12
XTAP_TAPCELL_ROW_11_172 VGND VPWR sky130_fd_sc_hd__tapvpwrvgnd_1
X_1325_ _0647_ _0648_ VGND VGND VPWR VPWR _0650_ sky130_fd_sc_hd__nor2_1
XTAP_TAPCELL_ROW_3_129 VGND VPWR sky130_fd_sc_hd__tapvpwrvgnd_1
X_1256_ _0578_ _0579_ net154 net118 VGND VGND VPWR VPWR _0583_ sky130_fd_sc_hd__nand4_1
X_1187_ _0509_ _0511_ _0514_ VGND VGND VPWR VPWR _0516_ sky130_fd_sc_hd__a21o_1
XPHY_EDGE_ROW_42_Left_95 VGND VGND VPWR VPWR sky130_fd_sc_hd__decap_3
XTAP_TAPCELL_ROW_17_209 VGND VPWR sky130_fd_sc_hd__tapvpwrvgnd_1
XTAP_TAPCELL_ROW_25_253 VGND VPWR sky130_fd_sc_hd__tapvpwrvgnd_1
XFILLER_2_195 VGND VGND VPWR VPWR sky130_fd_sc_hd__fill_1
X_1110_ _0437_ _0438_ _0362_ _0365_ VGND VGND VPWR VPWR _0440_ sky130_fd_sc_hd__o2bb2ai_4
XTAP_TAPCELL_ROW_48_378 VGND VPWR sky130_fd_sc_hd__tapvpwrvgnd_1
X_1041_ _0359_ _0361_ _0366_ _0367_ VGND VGND VPWR VPWR _0372_ sky130_fd_sc_hd__a22o_1
XFILLER_21_228 VPWR VGND VPWR VGND sky130_ef_sc_hd__decap_12
X_0825_ product_reg\[15\] net43 VGND VGND VPWR VPWR _0188_ sky130_fd_sc_hd__nand2_1
XFILLER_9_74 VGND VGND VPWR VPWR sky130_fd_sc_hd__fill_1
X_0687_ net397 VGND VGND VPWR VPWR _0067_ sky130_fd_sc_hd__inv_2
X_0756_ _0119_ net362 _0125_ VGND VGND VPWR VPWR _0128_ sky130_fd_sc_hd__and3_1
XFILLER_44_309 VGND VGND VPWR VPWR sky130_fd_sc_hd__fill_2
X_1239_ _0509_ _0511_ _0559_ _0561_ VGND VGND VPWR VPWR _0566_ sky130_fd_sc_hd__nand4_4
X_1308_ net163 net116 VGND VGND VPWR VPWR _0633_ sky130_fd_sc_hd__nand2_1
XFILLER_44_27 VGND VGND VPWR VPWR sky130_fd_sc_hd__fill_1
XFILLER_12_239 VGND VGND VPWR VPWR sky130_fd_sc_hd__decap_4
XFILLER_20_250 VGND VGND VPWR VPWR sky130_fd_sc_hd__fill_2
XTAP_TAPCELL_ROW_22_234 VGND VPWR sky130_fd_sc_hd__tapvpwrvgnd_1
XFILLER_47_169 VGND VGND VPWR VPWR sky130_fd_sc_hd__decap_3
XTAP_TAPCELL_ROW_45_359 VGND VPWR sky130_fd_sc_hd__tapvpwrvgnd_1
XFILLER_11_261 VPWR VGND VPWR VGND sky130_ef_sc_hd__decap_12
XFILLER_50_70 VPWR VGND VPWR VGND sky130_ef_sc_hd__decap_12
XFILLER_15_3 VPWR VGND VPWR VGND sky130_ef_sc_hd__decap_12
X_1024_ _0341_ _0347_ _0345_ _0337_ net74 VGND VGND VPWR VPWR _0355_ sky130_fd_sc_hd__o2111ai_4
XFILLER_26_309 VGND VGND VPWR VPWR sky130_fd_sc_hd__fill_2
X_0808_ product_reg\[13\] net41 VGND VGND VPWR VPWR _0173_ sky130_fd_sc_hd__or2_1
X_0739_ _0111_ _0112_ VGND VGND VPWR VPWR _0113_ sky130_fd_sc_hd__nand2_1
XFILLER_39_38 VGND VGND VPWR VPWR sky130_fd_sc_hd__decap_6
XFILLER_52_161 VGND VGND VPWR VPWR sky130_fd_sc_hd__decap_3
XFILLER_29_169 VGND VGND VPWR VPWR sky130_fd_sc_hd__decap_4
XTAP_TAPCELL_ROW_41_340 VGND VPWR sky130_fd_sc_hd__tapvpwrvgnd_1
XANTENNA_2 net5 VGND VGND VPWR VPWR sky130_fd_sc_hd__diode_2
XFILLER_6_53 VPWR VGND VPWR VGND sky130_ef_sc_hd__decap_12
XFILLER_6_97 VPWR VGND VPWR VGND sky130_ef_sc_hd__decap_12
Xrebuffer14 _0396_ VGND VGND VPWR VPWR net149 sky130_fd_sc_hd__buf_6
Xrebuffer36 net170 VGND VGND VPWR VPWR net171 sky130_fd_sc_hd__buf_1
X_1007_ _0302_ _0324_ _0332_ _0333_ VGND VGND VPWR VPWR _0338_ sky130_fd_sc_hd__a2bb2oi_2
Xrebuffer47 _0405_ VGND VGND VPWR VPWR net182 sky130_fd_sc_hd__dlymetal6s2s_1
Xrebuffer25 _0535_ VGND VGND VPWR VPWR net160 sky130_fd_sc_hd__buf_2
Xrebuffer58 net192 VGND VGND VPWR VPWR net193 sky130_fd_sc_hd__clkbuf_2
XFILLER_26_128 VGND VGND VPWR VPWR sky130_fd_sc_hd__fill_2
XFILLER_34_194 VGND VGND VPWR VPWR sky130_fd_sc_hd__fill_2
Xrebuffer126 _0453_ VGND VGND VPWR VPWR net261 sky130_fd_sc_hd__dlymetal6s2s_1
XFILLER_1_205 VPWR VGND VPWR VGND sky130_ef_sc_hd__decap_12
XFILLER_1_249 VPWR VGND VPWR VGND sky130_ef_sc_hd__decap_12
XFILLER_40_153 VGND VGND VPWR VPWR sky130_fd_sc_hd__decap_6
XFILLER_9_305 VGND VGND VPWR VPWR sky130_fd_sc_hd__decap_6
Xoutput61 net61 VGND VGND VPWR VPWR psum[31] sky130_fd_sc_hd__buf_2
Xoutput50 net50 VGND VGND VPWR VPWR psum[21] sky130_fd_sc_hd__buf_2
XFILLER_48_231 VGND VGND VPWR VPWR sky130_fd_sc_hd__decap_6
XFILLER_0_293 VPWR VGND VPWR VGND sky130_ef_sc_hd__decap_12
XFILLER_31_131 VPWR VGND VPWR VGND sky130_ef_sc_hd__decap_12
XTAP_TAPCELL_ROW_52_402 VGND VPWR sky130_fd_sc_hd__tapvpwrvgnd_1
XFILLER_52_27 VGND VGND VPWR VPWR sky130_fd_sc_hd__fill_1
XFILLER_10_304 VGND VGND VPWR VPWR sky130_fd_sc_hd__fill_1
XFILLER_45_212 VGND VGND VPWR VPWR sky130_fd_sc_hd__decap_3
XFILLER_42_60 VGND VGND VPWR VPWR sky130_fd_sc_hd__fill_2
XFILLER_13_175 VGND VGND VPWR VPWR sky130_fd_sc_hd__fill_2
XFILLER_13_197 VGND VGND VPWR VPWR sky130_fd_sc_hd__fill_1
XFILLER_26_72 VGND VGND VPWR VPWR sky130_fd_sc_hd__decap_8
XFILLER_42_82 VGND VGND VPWR VPWR sky130_fd_sc_hd__fill_2
Xrebuffer5 _0396_ VGND VGND VPWR VPWR net140 sky130_fd_sc_hd__clkbuf_2
X_1410_ clknet_3_5__leaf_clk _0036_ VGND VGND VPWR VPWR net22 sky130_fd_sc_hd__dfxtp_1
X_1341_ _0640_ _0644_ _0664_ VGND VGND VPWR VPWR _0665_ sky130_fd_sc_hd__o21a_1
X_1272_ _0570_ _0596_ _0597_ VGND VGND VPWR VPWR _0599_ sky130_fd_sc_hd__and3_1
XTAP_TAPCELL_ROW_14_192 VGND VPWR sky130_fd_sc_hd__tapvpwrvgnd_1
X_0987_ _0318_ net376 _0317_ VGND VGND VPWR VPWR _0319_ sky130_fd_sc_hd__o21ai_4
XTAP_TAPCELL_ROW_6_149 VGND VPWR sky130_fd_sc_hd__tapvpwrvgnd_1
Xfanout103 net5 VGND VGND VPWR VPWR net103 sky130_fd_sc_hd__buf_12
Xfanout125 net12 VGND VGND VPWR VPWR net125 sky130_fd_sc_hd__buf_4
Xfanout114 net16 VGND VGND VPWR VPWR net114 sky130_fd_sc_hd__clkbuf_4
XFILLER_47_27 VPWR VGND VPWR VGND sky130_ef_sc_hd__decap_12
XPHY_EDGE_ROW_16_Right_16 VGND VGND VPWR VPWR sky130_fd_sc_hd__decap_3
X_0841_ net45 net71 net44 net46 VGND VGND VPWR VPWR _0201_ sky130_fd_sc_hd__a31o_1
XFILLER_41_281 VGND VGND VPWR VPWR sky130_fd_sc_hd__decap_8
X_0772_ _0132_ _0141_ _0140_ VGND VGND VPWR VPWR _0142_ sky130_fd_sc_hd__a21oi_1
X_0910_ net395 net84 _0085_ _0244_ VGND VGND VPWR VPWR _0045_ sky130_fd_sc_hd__a31o_1
XTAP_TAPCELL_ROW_11_173 VGND VPWR sky130_fd_sc_hd__tapvpwrvgnd_1
XPHY_EDGE_ROW_25_Right_25 VGND VGND VPWR VPWR sky130_fd_sc_hd__decap_3
XFILLER_45_3 VPWR VGND VPWR VGND sky130_ef_sc_hd__decap_12
XFILLER_5_193 VPWR VGND VPWR VGND sky130_ef_sc_hd__decap_12
X_1324_ _0646_ _0645_ VGND VGND VPWR VPWR _0649_ sky130_fd_sc_hd__nand2b_1
XPHY_EDGE_ROW_34_Right_34 VGND VGND VPWR VPWR sky130_fd_sc_hd__decap_3
X_1186_ _0375_ _0444_ _0513_ VGND VGND VPWR VPWR _0515_ sky130_fd_sc_hd__o21ai_2
X_1255_ net154 net118 _0578_ _0579_ VGND VGND VPWR VPWR _0582_ sky130_fd_sc_hd__a22o_1
XTAP_TAPCELL_ROW_34_298 VGND VPWR sky130_fd_sc_hd__tapvpwrvgnd_1
XPHY_EDGE_ROW_43_Right_43 VGND VGND VPWR VPWR sky130_fd_sc_hd__decap_3
XPHY_EDGE_ROW_52_Right_52 VGND VGND VPWR VPWR sky130_fd_sc_hd__decap_3
XFILLER_23_270 VGND VGND VPWR VPWR sky130_fd_sc_hd__decap_8
XFILLER_2_141 VPWR VGND VPWR VGND sky130_ef_sc_hd__decap_12
XFILLER_48_81 VGND VGND VPWR VPWR sky130_fd_sc_hd__decap_3
Xclone235 net72 VGND VGND VPWR VPWR net370 sky130_fd_sc_hd__buf_6
X_1040_ _0359_ _0361_ _0369_ VGND VGND VPWR VPWR _0371_ sky130_fd_sc_hd__nand3_1
XTAP_TAPCELL_ROW_48_379 VGND VPWR sky130_fd_sc_hd__tapvpwrvgnd_1
XFILLER_0_55 VGND VGND VPWR VPWR sky130_fd_sc_hd__fill_1
X_0824_ product_reg\[15\] net43 VGND VGND VPWR VPWR _0187_ sky130_fd_sc_hd__or2_1
X_0755_ _0119_ net362 _0125_ VGND VGND VPWR VPWR _0127_ sky130_fd_sc_hd__a21oi_1
X_1238_ product_reg\[9\] _0232_ _0565_ VGND VGND VPWR VPWR _0052_ sky130_fd_sc_hd__a21o_1
X_1307_ net164 net116 VGND VGND VPWR VPWR _0632_ sky130_fd_sc_hd__and2_1
X_1169_ _0493_ _0497_ _0491_ VGND VGND VPWR VPWR _0498_ sky130_fd_sc_hd__nand3_4
XTAP_TAPCELL_ROW_22_235 VGND VPWR sky130_fd_sc_hd__tapvpwrvgnd_1
Xclkbuf_3_0__f_clk clknet_0_clk VGND VGND VPWR VPWR clknet_3_0__leaf_clk sky130_fd_sc_hd__clkbuf_16
XFILLER_47_126 VGND VGND VPWR VPWR sky130_fd_sc_hd__decap_8
XFILLER_50_93 VGND VGND VPWR VPWR sky130_fd_sc_hd__fill_1
XFILLER_50_82 VGND VGND VPWR VPWR sky130_fd_sc_hd__fill_2
XFILLER_7_211 VPWR VGND VPWR VGND sky130_ef_sc_hd__decap_12
XFILLER_11_273 VGND VGND VPWR VPWR sky130_fd_sc_hd__decap_6
XFILLER_46_170 VGND VGND VPWR VPWR sky130_fd_sc_hd__fill_1
XFILLER_38_137 VGND VGND VPWR VPWR sky130_fd_sc_hd__decap_3
X_1023_ _0337_ _0350_ VGND VGND VPWR VPWR _0354_ sky130_fd_sc_hd__nand2_4
X_0807_ net79 net408 net83 _0172_ VGND VGND VPWR VPWR _0013_ sky130_fd_sc_hd__o211a_1
X_0738_ product_reg\[4\] net63 VGND VGND VPWR VPWR _0112_ sky130_fd_sc_hd__or2_1
XPHY_EDGE_ROW_2_Right_2 VGND VGND VPWR VPWR sky130_fd_sc_hd__decap_3
XFILLER_52_195 VGND VGND VPWR VPWR sky130_fd_sc_hd__fill_1
XFILLER_44_118 VGND VGND VPWR VPWR sky130_fd_sc_hd__fill_2
XFILLER_20_85 VGND VGND VPWR VPWR sky130_fd_sc_hd__fill_1
XTAP_TAPCELL_ROW_41_341 VGND VPWR sky130_fd_sc_hd__tapvpwrvgnd_1
XFILLER_6_65 VPWR VGND VPWR VGND sky130_ef_sc_hd__decap_12
Xrebuffer37 _0511_ VGND VGND VPWR VPWR net172 sky130_fd_sc_hd__buf_6
X_1006_ _0325_ _0332_ _0333_ VGND VGND VPWR VPWR _0337_ sky130_fd_sc_hd__nand3_4
Xrebuffer48 _0455_ VGND VGND VPWR VPWR net183 sky130_fd_sc_hd__clkbuf_1
Xrebuffer59 net193 VGND VGND VPWR VPWR net194 sky130_fd_sc_hd__dlygate4sd1_1
Xrebuffer26 net98 VGND VGND VPWR VPWR net161 sky130_fd_sc_hd__dlygate4sd1_1
Xrebuffer15 _0498_ VGND VGND VPWR VPWR net150 sky130_fd_sc_hd__buf_6
Xrebuffer127 net261 VGND VGND VPWR VPWR net262 sky130_fd_sc_hd__dlygate4sd1_1
XFILLER_1_217 VGND VGND VPWR VPWR sky130_fd_sc_hd__decap_6
Xoutput40 net40 VGND VGND VPWR VPWR psum[12] sky130_fd_sc_hd__buf_2
Xoutput51 net51 VGND VGND VPWR VPWR psum[22] sky130_fd_sc_hd__buf_2
Xoutput62 net62 VGND VGND VPWR VPWR psum[3] sky130_fd_sc_hd__buf_2
XFILLER_31_176 VGND VGND VPWR VPWR sky130_fd_sc_hd__decap_4
XFILLER_39_232 VGND VGND VPWR VPWR sky130_fd_sc_hd__fill_1
XTAP_TAPCELL_ROW_52_403 VGND VPWR sky130_fd_sc_hd__tapvpwrvgnd_1
XFILLER_6_309 VGND VGND VPWR VPWR sky130_fd_sc_hd__fill_2
XFILLER_9_169 VGND VGND VPWR VPWR sky130_fd_sc_hd__decap_4
X_1340_ _0658_ _0663_ VGND VGND VPWR VPWR _0664_ sky130_fd_sc_hd__xnor2_1
Xrebuffer6 _0396_ VGND VGND VPWR VPWR net141 sky130_fd_sc_hd__buf_6
X_1271_ _0596_ _0597_ _0570_ VGND VGND VPWR VPWR _0598_ sky130_fd_sc_hd__a21oi_1
XFILLER_3_55 VGND VGND VPWR VPWR sky130_fd_sc_hd__fill_1
XTAP_TAPCELL_ROW_14_193 VGND VPWR sky130_fd_sc_hd__tapvpwrvgnd_1
X_0986_ _0316_ _0275_ VGND VGND VPWR VPWR _0318_ sky130_fd_sc_hd__nand2_4
Xfanout104 net106 VGND VGND VPWR VPWR net104 sky130_fd_sc_hd__buf_4
Xfanout126 net12 VGND VGND VPWR VPWR net126 sky130_fd_sc_hd__buf_4
Xfanout115 net16 VGND VGND VPWR VPWR net115 sky130_fd_sc_hd__buf_2
XFILLER_47_39 VPWR VGND VPWR VGND sky130_ef_sc_hd__decap_12
XFILLER_50_282 VGND VGND VPWR VPWR sky130_fd_sc_hd__fill_1
XFILLER_50_260 VPWR VGND VPWR VGND sky130_ef_sc_hd__decap_12
XFILLER_6_139 VGND VGND VPWR VPWR sky130_fd_sc_hd__fill_1
XFILLER_5_3 VPWR VGND VPWR VGND sky130_ef_sc_hd__decap_12
XFILLER_2_301 VGND VGND VPWR VPWR sky130_fd_sc_hd__decap_6
XFILLER_18_246 VGND VGND VPWR VPWR sky130_fd_sc_hd__fill_2
XFILLER_26_290 VGND VGND VPWR VPWR sky130_fd_sc_hd__fill_2
X_0840_ _0200_ _0199_ net86 VGND VGND VPWR VPWR _0018_ sky130_fd_sc_hd__and3_1
X_0771_ _0068_ _0071_ _0129_ _0123_ VGND VGND VPWR VPWR _0141_ sky130_fd_sc_hd__o211ai_2
XTAP_TAPCELL_ROW_11_174 VGND VPWR sky130_fd_sc_hd__tapvpwrvgnd_1
X_1323_ _0646_ _0645_ VGND VGND VPWR VPWR _0648_ sky130_fd_sc_hd__and2b_1
XFILLER_5_161 VGND VGND VPWR VPWR sky130_fd_sc_hd__decap_6
X_1185_ _0442_ _0446_ _0379_ _0445_ VGND VGND VPWR VPWR _0514_ sky130_fd_sc_hd__o22ai_2
X_1254_ _0578_ _0579_ _0576_ VGND VGND VPWR VPWR _0581_ sky130_fd_sc_hd__a21oi_1
XTAP_TAPCELL_ROW_34_299 VGND VPWR sky130_fd_sc_hd__tapvpwrvgnd_1
XFILLER_33_19 VGND VGND VPWR VPWR sky130_fd_sc_hd__decap_4
X_0969_ net133 net5 net156 net90 VGND VGND VPWR VPWR _0301_ sky130_fd_sc_hd__a22o_1
XFILLER_2_197 VPWR VGND VPWR VGND sky130_ef_sc_hd__decap_12
XFILLER_2_153 VPWR VGND VPWR VGND sky130_ef_sc_hd__decap_12
Xclone236 _0197_ VGND VGND VPWR VPWR net371 sky130_fd_sc_hd__buf_6
XTAP_TAPCELL_ROW_16_200 VGND VPWR sky130_fd_sc_hd__tapvpwrvgnd_1
X_0823_ net79 net410 net87 _0186_ VGND VGND VPWR VPWR _0015_ sky130_fd_sc_hd__o211a_1
X_0754_ _0069_ _0072_ _0113_ _0110_ _0111_ VGND VGND VPWR VPWR _0126_ sky130_fd_sc_hd__o221ai_4
X_1306_ _0607_ _0609_ VGND VGND VPWR VPWR _0631_ sky130_fd_sc_hd__nand2_1
XFILLER_44_29 VPWR VGND VPWR VGND sky130_ef_sc_hd__decap_12
X_1237_ _0558_ _0560_ _0563_ _0000_ _0564_ VGND VGND VPWR VPWR _0565_ sky130_fd_sc_hd__o311a_1
X_1099_ _0422_ _0425_ _0426_ VGND VGND VPWR VPWR _0429_ sky130_fd_sc_hd__a21oi_4
X_1168_ _0392_ net139 _0430_ VGND VGND VPWR VPWR _0497_ sky130_fd_sc_hd__o21ai_2
XTAP_TAPCELL_ROW_22_236 VGND VPWR sky130_fd_sc_hd__tapvpwrvgnd_1
XTAP_TAPCELL_ROW_30_280 VGND VPWR sky130_fd_sc_hd__tapvpwrvgnd_1
XFILLER_34_73 VGND VGND VPWR VPWR sky130_fd_sc_hd__fill_1
XFILLER_7_223 VGND VGND VPWR VPWR sky130_fd_sc_hd__fill_1
XFILLER_38_105 VGND VGND VPWR VPWR sky130_fd_sc_hd__decap_8
XFILLER_46_193 VGND VGND VPWR VPWR sky130_fd_sc_hd__decap_3
X_1022_ _0337_ net74 net344 _0348_ VGND VGND VPWR VPWR _0353_ sky130_fd_sc_hd__o2bb2ai_4
X_0806_ _0170_ _0171_ _0070_ VGND VGND VPWR VPWR _0172_ sky130_fd_sc_hd__a21o_1
X_0737_ product_reg\[4\] net63 VGND VGND VPWR VPWR _0111_ sky130_fd_sc_hd__nand2_2
XFILLER_52_141 VGND VGND VPWR VPWR sky130_fd_sc_hd__fill_2
XTAP_TAPCELL_ROW_50_386 VGND VPWR sky130_fd_sc_hd__tapvpwrvgnd_1
XFILLER_20_75 VGND VGND VPWR VPWR sky130_fd_sc_hd__decap_4
XFILLER_28_193 VGND VGND VPWR VPWR sky130_fd_sc_hd__decap_3
XFILLER_6_77 VGND VGND VPWR VPWR sky130_fd_sc_hd__decap_6
XFILLER_3_281 VPWR VGND VPWR VGND sky130_ef_sc_hd__decap_12
XPHY_EDGE_ROW_16_Left_69 VGND VGND VPWR VPWR sky130_fd_sc_hd__decap_3
Xrebuffer27 net161 VGND VGND VPWR VPWR net162 sky130_fd_sc_hd__dlygate4sd1_1
Xrebuffer16 _0477_ VGND VGND VPWR VPWR net151 sky130_fd_sc_hd__buf_6
X_1005_ net171 _0335_ _0334_ VGND VGND VPWR VPWR _0336_ sky130_fd_sc_hd__o21ai_1
Xrebuffer38 _0407_ VGND VGND VPWR VPWR net173 sky130_fd_sc_hd__buf_1
Xrebuffer49 _0477_ VGND VGND VPWR VPWR net184 sky130_fd_sc_hd__buf_1
XFILLER_17_119 VGND VGND VPWR VPWR sky130_fd_sc_hd__decap_3
Xoutput52 net52 VGND VGND VPWR VPWR psum[23] sky130_fd_sc_hd__buf_2
Xoutput41 net41 VGND VGND VPWR VPWR psum[13] sky130_fd_sc_hd__buf_2
Xoutput30 net30 VGND VGND VPWR VPWR b_out[1] sky130_fd_sc_hd__buf_2
Xoutput63 net63 VGND VGND VPWR VPWR psum[4] sky130_fd_sc_hd__buf_2
XFILLER_16_141 VGND VGND VPWR VPWR sky130_fd_sc_hd__decap_8
XFILLER_31_199 VGND VGND VPWR VPWR sky130_fd_sc_hd__fill_1
.ends
