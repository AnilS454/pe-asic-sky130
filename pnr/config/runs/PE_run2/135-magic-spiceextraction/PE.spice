* NGSPICE file created from PE.ext - technology: sky130A

* Black-box entry subcircuit for sky130_fd_sc_hd__fill_1 abstract view
.subckt sky130_fd_sc_hd__fill_1 VGND VNB VPB VPWR
.ends

* Black-box entry subcircuit for sky130_fd_sc_hd__fill_2 abstract view
.subckt sky130_fd_sc_hd__fill_2 VGND VNB VPB VPWR
.ends

* Black-box entry subcircuit for sky130_fd_sc_hd__dlygate4sd1_1 abstract view
.subckt sky130_fd_sc_hd__dlygate4sd1_1 A VGND VNB VPB VPWR X
.ends

* Black-box entry subcircuit for sky130_fd_sc_hd__tapvpwrvgnd_1 abstract view
.subckt sky130_fd_sc_hd__tapvpwrvgnd_1 VGND VPWR
.ends

* Black-box entry subcircuit for sky130_fd_sc_hd__o21ai_1 abstract view
.subckt sky130_fd_sc_hd__o21ai_1 A1 A2 B1 VGND VNB VPB VPWR Y
.ends

* Black-box entry subcircuit for sky130_fd_sc_hd__decap_4 abstract view
.subckt sky130_fd_sc_hd__decap_4 VGND VNB VPB VPWR
.ends

* Black-box entry subcircuit for sky130_fd_sc_hd__o2bb2ai_2 abstract view
.subckt sky130_fd_sc_hd__o2bb2ai_2 A1_N A2_N B1 B2 VGND VNB VPB VPWR Y
.ends

* Black-box entry subcircuit for sky130_fd_sc_hd__dfxtp_1 abstract view
.subckt sky130_fd_sc_hd__dfxtp_1 CLK D VGND VNB VPB VPWR Q
.ends

* Black-box entry subcircuit for sky130_fd_sc_hd__buf_4 abstract view
.subckt sky130_fd_sc_hd__buf_4 A VGND VNB VPB VPWR X
.ends

* Black-box entry subcircuit for sky130_fd_sc_hd__clkbuf_2 abstract view
.subckt sky130_fd_sc_hd__clkbuf_2 A VGND VNB VPB VPWR X
.ends

* Black-box entry subcircuit for sky130_fd_sc_hd__clkbuf_4 abstract view
.subckt sky130_fd_sc_hd__clkbuf_4 A VGND VNB VPB VPWR X
.ends

* Black-box entry subcircuit for sky130_fd_sc_hd__dlygate4sd3_1 abstract view
.subckt sky130_fd_sc_hd__dlygate4sd3_1 A VGND VNB VPB VPWR X
.ends

* Black-box entry subcircuit for sky130_fd_sc_hd__nand2_1 abstract view
.subckt sky130_fd_sc_hd__nand2_1 A B VGND VNB VPB VPWR Y
.ends

* Black-box entry subcircuit for sky130_fd_sc_hd__and3_1 abstract view
.subckt sky130_fd_sc_hd__and3_1 A B C VGND VNB VPB VPWR X
.ends

* Black-box entry subcircuit for sky130_fd_sc_hd__a211oi_1 abstract view
.subckt sky130_fd_sc_hd__a211oi_1 A1 A2 B1 C1 VGND VNB VPB VPWR Y
.ends

* Black-box entry subcircuit for sky130_fd_sc_hd__o21ai_4 abstract view
.subckt sky130_fd_sc_hd__o21ai_4 A1 A2 B1 VGND VNB VPB VPWR Y
.ends

* Black-box entry subcircuit for sky130_fd_sc_hd__a22oi_4 abstract view
.subckt sky130_fd_sc_hd__a22oi_4 A1 A2 B1 B2 VGND VNB VPB VPWR Y
.ends

* Black-box entry subcircuit for sky130_fd_sc_hd__a22o_1 abstract view
.subckt sky130_fd_sc_hd__a22o_1 A1 A2 B1 B2 VGND VNB VPB VPWR X
.ends

* Black-box entry subcircuit for sky130_fd_sc_hd__a21o_1 abstract view
.subckt sky130_fd_sc_hd__a21o_1 A1 A2 B1 VGND VNB VPB VPWR X
.ends

* Black-box entry subcircuit for sky130_fd_sc_hd__and2_1 abstract view
.subckt sky130_fd_sc_hd__and2_1 A B VGND VNB VPB VPWR X
.ends

* Black-box entry subcircuit for sky130_fd_sc_hd__a21oi_1 abstract view
.subckt sky130_fd_sc_hd__a21oi_1 A1 A2 B1 VGND VNB VPB VPWR Y
.ends

* Black-box entry subcircuit for sky130_fd_sc_hd__o211ai_4 abstract view
.subckt sky130_fd_sc_hd__o211ai_4 A1 A2 B1 C1 VGND VNB VPB VPWR Y
.ends

* Black-box entry subcircuit for sky130_fd_sc_hd__decap_8 abstract view
.subckt sky130_fd_sc_hd__decap_8 VGND VNB VPB VPWR
.ends

* Black-box entry subcircuit for sky130_fd_sc_hd__a21oi_4 abstract view
.subckt sky130_fd_sc_hd__a21oi_4 A1 A2 B1 VGND VNB VPB VPWR Y
.ends

* Black-box entry subcircuit for sky130_fd_sc_hd__o21bai_2 abstract view
.subckt sky130_fd_sc_hd__o21bai_2 A1 A2 B1_N VGND VNB VPB VPWR Y
.ends

* Black-box entry subcircuit for sky130_fd_sc_hd__decap_3 abstract view
.subckt sky130_fd_sc_hd__decap_3 VGND VNB VPB VPWR
.ends

* Black-box entry subcircuit for sky130_ef_sc_hd__decap_12 abstract view
.subckt sky130_ef_sc_hd__decap_12 VPWR VGND VPB VNB
.ends

* Black-box entry subcircuit for sky130_fd_sc_hd__dlymetal6s4s_1 abstract view
.subckt sky130_fd_sc_hd__dlymetal6s4s_1 A VGND VNB VPB VPWR X
.ends

* Black-box entry subcircuit for sky130_fd_sc_hd__a41o_1 abstract view
.subckt sky130_fd_sc_hd__a41o_1 A1 A2 A3 A4 B1 VGND VNB VPB VPWR X
.ends

* Black-box entry subcircuit for sky130_fd_sc_hd__buf_2 abstract view
.subckt sky130_fd_sc_hd__buf_2 A VGND VNB VPB VPWR X
.ends

* Black-box entry subcircuit for sky130_fd_sc_hd__clkbuf_16 abstract view
.subckt sky130_fd_sc_hd__clkbuf_16 A VGND VNB VPB VPWR X
.ends

* Black-box entry subcircuit for sky130_fd_sc_hd__buf_1 abstract view
.subckt sky130_fd_sc_hd__buf_1 A VGND VNB VPB VPWR X
.ends

* Black-box entry subcircuit for sky130_fd_sc_hd__nand3_2 abstract view
.subckt sky130_fd_sc_hd__nand3_2 A B C VGND VNB VPB VPWR Y
.ends

* Black-box entry subcircuit for sky130_fd_sc_hd__buf_6 abstract view
.subckt sky130_fd_sc_hd__buf_6 A VGND VNB VPB VPWR X
.ends

* Black-box entry subcircuit for sky130_fd_sc_hd__nand4_4 abstract view
.subckt sky130_fd_sc_hd__nand4_4 A B C D VGND VNB VPB VPWR Y
.ends

* Black-box entry subcircuit for sky130_fd_sc_hd__o21ai_2 abstract view
.subckt sky130_fd_sc_hd__o21ai_2 A1 A2 B1 VGND VNB VPB VPWR Y
.ends

* Black-box entry subcircuit for sky130_fd_sc_hd__nand4_1 abstract view
.subckt sky130_fd_sc_hd__nand4_1 A B C D VGND VNB VPB VPWR Y
.ends

* Black-box entry subcircuit for sky130_fd_sc_hd__o211ai_2 abstract view
.subckt sky130_fd_sc_hd__o211ai_2 A1 A2 B1 C1 VGND VNB VPB VPWR Y
.ends

* Black-box entry subcircuit for sky130_fd_sc_hd__or2_1 abstract view
.subckt sky130_fd_sc_hd__or2_1 A B VGND VNB VPB VPWR X
.ends

* Black-box entry subcircuit for sky130_fd_sc_hd__o21a_1 abstract view
.subckt sky130_fd_sc_hd__o21a_1 A1 A2 B1 VGND VNB VPB VPWR X
.ends

* Black-box entry subcircuit for sky130_fd_sc_hd__a21o_4 abstract view
.subckt sky130_fd_sc_hd__a21o_4 A1 A2 B1 VGND VNB VPB VPWR X
.ends

* Black-box entry subcircuit for sky130_fd_sc_hd__o2111ai_4 abstract view
.subckt sky130_fd_sc_hd__o2111ai_4 A1 A2 B1 C1 D1 VGND VNB VPB VPWR Y
.ends

* Black-box entry subcircuit for sky130_fd_sc_hd__o211a_1 abstract view
.subckt sky130_fd_sc_hd__o211a_1 A1 A2 B1 C1 VGND VNB VPB VPWR X
.ends

* Black-box entry subcircuit for sky130_fd_sc_hd__buf_8 abstract view
.subckt sky130_fd_sc_hd__buf_8 A VGND VNB VPB VPWR X
.ends

* Black-box entry subcircuit for sky130_fd_sc_hd__dlymetal6s2s_1 abstract view
.subckt sky130_fd_sc_hd__dlymetal6s2s_1 A VGND VNB VPB VPWR X
.ends

* Black-box entry subcircuit for sky130_fd_sc_hd__nor2_1 abstract view
.subckt sky130_fd_sc_hd__nor2_1 A B VGND VNB VPB VPWR Y
.ends

* Black-box entry subcircuit for sky130_fd_sc_hd__a22o_2 abstract view
.subckt sky130_fd_sc_hd__a22o_2 A1 A2 B1 B2 VGND VNB VPB VPWR X
.ends

* Black-box entry subcircuit for sky130_fd_sc_hd__o22a_1 abstract view
.subckt sky130_fd_sc_hd__o22a_1 A1 A2 B1 B2 VGND VNB VPB VPWR X
.ends

* Black-box entry subcircuit for sky130_fd_sc_hd__a211o_1 abstract view
.subckt sky130_fd_sc_hd__a211o_1 A1 A2 B1 C1 VGND VNB VPB VPWR X
.ends

* Black-box entry subcircuit for sky130_fd_sc_hd__a21oi_2 abstract view
.subckt sky130_fd_sc_hd__a21oi_2 A1 A2 B1 VGND VNB VPB VPWR Y
.ends

* Black-box entry subcircuit for sky130_fd_sc_hd__nor2_4 abstract view
.subckt sky130_fd_sc_hd__nor2_4 A B VGND VNB VPB VPWR Y
.ends

* Black-box entry subcircuit for sky130_fd_sc_hd__a22oi_2 abstract view
.subckt sky130_fd_sc_hd__a22oi_2 A1 A2 B1 B2 VGND VNB VPB VPWR Y
.ends

* Black-box entry subcircuit for sky130_fd_sc_hd__a2111oi_1 abstract view
.subckt sky130_fd_sc_hd__a2111oi_1 A1 A2 B1 C1 D1 VGND VNB VPB VPWR Y
.ends

* Black-box entry subcircuit for sky130_fd_sc_hd__o211ai_1 abstract view
.subckt sky130_fd_sc_hd__o211ai_1 A1 A2 B1 C1 VGND VNB VPB VPWR Y
.ends

* Black-box entry subcircuit for sky130_fd_sc_hd__o221ai_4 abstract view
.subckt sky130_fd_sc_hd__o221ai_4 A1 A2 B1 B2 C1 VGND VNB VPB VPWR Y
.ends

* Black-box entry subcircuit for sky130_fd_sc_hd__and4_1 abstract view
.subckt sky130_fd_sc_hd__and4_1 A B C D VGND VNB VPB VPWR X
.ends

* Black-box entry subcircuit for sky130_fd_sc_hd__nand2_2 abstract view
.subckt sky130_fd_sc_hd__nand2_2 A B VGND VNB VPB VPWR Y
.ends

* Black-box entry subcircuit for sky130_fd_sc_hd__o22ai_1 abstract view
.subckt sky130_fd_sc_hd__o22ai_1 A1 A2 B1 B2 VGND VNB VPB VPWR Y
.ends

* Black-box entry subcircuit for sky130_fd_sc_hd__nand3_1 abstract view
.subckt sky130_fd_sc_hd__nand3_1 A B C VGND VNB VPB VPWR Y
.ends

* Black-box entry subcircuit for sky130_fd_sc_hd__bufinv_16 abstract view
.subckt sky130_fd_sc_hd__bufinv_16 A VGND VNB VPB VPWR Y
.ends

* Black-box entry subcircuit for sky130_fd_sc_hd__nand3_4 abstract view
.subckt sky130_fd_sc_hd__nand3_4 A B C VGND VNB VPB VPWR Y
.ends

* Black-box entry subcircuit for sky130_fd_sc_hd__a22oi_1 abstract view
.subckt sky130_fd_sc_hd__a22oi_1 A1 A2 B1 B2 VGND VNB VPB VPWR Y
.ends

* Black-box entry subcircuit for sky130_fd_sc_hd__nor2_2 abstract view
.subckt sky130_fd_sc_hd__nor2_2 A B VGND VNB VPB VPWR Y
.ends

* Black-box entry subcircuit for sky130_fd_sc_hd__decap_6 abstract view
.subckt sky130_fd_sc_hd__decap_6 VGND VNB VPB VPWR
.ends

* Black-box entry subcircuit for sky130_fd_sc_hd__buf_12 abstract view
.subckt sky130_fd_sc_hd__buf_12 A VGND VNB VPB VPWR X
.ends

* Black-box entry subcircuit for sky130_fd_sc_hd__a22o_4 abstract view
.subckt sky130_fd_sc_hd__a22o_4 A1 A2 B1 B2 VGND VNB VPB VPWR X
.ends

* Black-box entry subcircuit for sky130_fd_sc_hd__nand2b_1 abstract view
.subckt sky130_fd_sc_hd__nand2b_1 A_N B VGND VNB VPB VPWR Y
.ends

* Black-box entry subcircuit for sky130_fd_sc_hd__clkinv_4 abstract view
.subckt sky130_fd_sc_hd__clkinv_4 A VGND VNB VPB VPWR Y
.ends

* Black-box entry subcircuit for sky130_fd_sc_hd__or2_4 abstract view
.subckt sky130_fd_sc_hd__or2_4 A B VGND VNB VPB VPWR X
.ends

* Black-box entry subcircuit for sky130_fd_sc_hd__o22ai_4 abstract view
.subckt sky130_fd_sc_hd__o22ai_4 A1 A2 B1 B2 VGND VNB VPB VPWR Y
.ends

* Black-box entry subcircuit for sky130_fd_sc_hd__nand4_2 abstract view
.subckt sky130_fd_sc_hd__nand4_2 A B C D VGND VNB VPB VPWR Y
.ends

* Black-box entry subcircuit for sky130_fd_sc_hd__dfxtp_2 abstract view
.subckt sky130_fd_sc_hd__dfxtp_2 CLK D VGND VNB VPB VPWR Q
.ends

* Black-box entry subcircuit for sky130_fd_sc_hd__o2bb2ai_1 abstract view
.subckt sky130_fd_sc_hd__o2bb2ai_1 A1_N A2_N B1 B2 VGND VNB VPB VPWR Y
.ends

* Black-box entry subcircuit for sky130_fd_sc_hd__o2111a_1 abstract view
.subckt sky130_fd_sc_hd__o2111a_1 A1 A2 B1 C1 D1 VGND VNB VPB VPWR X
.ends

* Black-box entry subcircuit for sky130_fd_sc_hd__a2bb2oi_4 abstract view
.subckt sky130_fd_sc_hd__a2bb2oi_4 A1_N A2_N B1 B2 VGND VNB VPB VPWR Y
.ends

* Black-box entry subcircuit for sky130_fd_sc_hd__o211a_4 abstract view
.subckt sky130_fd_sc_hd__o211a_4 A1 A2 B1 C1 VGND VNB VPB VPWR X
.ends

* Black-box entry subcircuit for sky130_fd_sc_hd__a31o_1 abstract view
.subckt sky130_fd_sc_hd__a31o_1 A1 A2 A3 B1 VGND VNB VPB VPWR X
.ends

* Black-box entry subcircuit for sky130_fd_sc_hd__o2bb2a_2 abstract view
.subckt sky130_fd_sc_hd__o2bb2a_2 A1_N A2_N B1 B2 VGND VNB VPB VPWR X
.ends

* Black-box entry subcircuit for sky130_fd_sc_hd__o22ai_2 abstract view
.subckt sky130_fd_sc_hd__o22ai_2 A1 A2 B1 B2 VGND VNB VPB VPWR Y
.ends

* Black-box entry subcircuit for sky130_fd_sc_hd__dfxtp_4 abstract view
.subckt sky130_fd_sc_hd__dfxtp_4 CLK D VGND VNB VPB VPWR Q
.ends

* Black-box entry subcircuit for sky130_fd_sc_hd__o2111ai_1 abstract view
.subckt sky130_fd_sc_hd__o2111ai_1 A1 A2 B1 C1 D1 VGND VNB VPB VPWR Y
.ends

* Black-box entry subcircuit for sky130_fd_sc_hd__inv_2 abstract view
.subckt sky130_fd_sc_hd__inv_2 A VGND VNB VPB VPWR Y
.ends

* Black-box entry subcircuit for sky130_fd_sc_hd__o2bb2ai_4 abstract view
.subckt sky130_fd_sc_hd__o2bb2ai_4 A1_N A2_N B1 B2 VGND VNB VPB VPWR Y
.ends

* Black-box entry subcircuit for sky130_fd_sc_hd__o311a_1 abstract view
.subckt sky130_fd_sc_hd__o311a_1 A1 A2 A3 B1 C1 VGND VNB VPB VPWR X
.ends

* Black-box entry subcircuit for sky130_fd_sc_hd__a41o_4 abstract view
.subckt sky130_fd_sc_hd__a41o_4 A1 A2 A3 A4 B1 VGND VNB VPB VPWR X
.ends

* Black-box entry subcircuit for sky130_fd_sc_hd__and4b_1 abstract view
.subckt sky130_fd_sc_hd__and4b_1 A_N B C D VGND VNB VPB VPWR X
.ends

* Black-box entry subcircuit for sky130_fd_sc_hd__o31a_1 abstract view
.subckt sky130_fd_sc_hd__o31a_1 A1 A2 A3 B1 VGND VNB VPB VPWR X
.ends

* Black-box entry subcircuit for sky130_fd_sc_hd__or4b_1 abstract view
.subckt sky130_fd_sc_hd__or4b_1 A B C D_N VGND VNB VPB VPWR X
.ends

* Black-box entry subcircuit for sky130_fd_sc_hd__o21bai_4 abstract view
.subckt sky130_fd_sc_hd__o21bai_4 A1 A2 B1_N VGND VNB VPB VPWR Y
.ends

* Black-box entry subcircuit for sky130_fd_sc_hd__a211oi_2 abstract view
.subckt sky130_fd_sc_hd__a211oi_2 A1 A2 B1 C1 VGND VNB VPB VPWR Y
.ends

* Black-box entry subcircuit for sky130_fd_sc_hd__nand3b_1 abstract view
.subckt sky130_fd_sc_hd__nand3b_1 A_N B C VGND VNB VPB VPWR Y
.ends

* Black-box entry subcircuit for sky130_fd_sc_hd__and4_2 abstract view
.subckt sky130_fd_sc_hd__and4_2 A B C D VGND VNB VPB VPWR X
.ends

* Black-box entry subcircuit for sky130_fd_sc_hd__nor3_2 abstract view
.subckt sky130_fd_sc_hd__nor3_2 A B C VGND VNB VPB VPWR Y
.ends

* Black-box entry subcircuit for sky130_fd_sc_hd__xor2_1 abstract view
.subckt sky130_fd_sc_hd__xor2_1 A B VGND VNB VPB VPWR X
.ends

* Black-box entry subcircuit for sky130_fd_sc_hd__a2bb2o_1 abstract view
.subckt sky130_fd_sc_hd__a2bb2o_1 A1_N A2_N B1 B2 VGND VNB VPB VPWR X
.ends

* Black-box entry subcircuit for sky130_fd_sc_hd__a31oi_1 abstract view
.subckt sky130_fd_sc_hd__a31oi_1 A1 A2 A3 B1 VGND VNB VPB VPWR Y
.ends

* Black-box entry subcircuit for sky130_fd_sc_hd__inv_4 abstract view
.subckt sky130_fd_sc_hd__inv_4 A VGND VNB VPB VPWR Y
.ends

* Black-box entry subcircuit for sky130_fd_sc_hd__clkbuf_1 abstract view
.subckt sky130_fd_sc_hd__clkbuf_1 A VGND VNB VPB VPWR X
.ends

* Black-box entry subcircuit for sky130_fd_sc_hd__a311oi_1 abstract view
.subckt sky130_fd_sc_hd__a311oi_1 A1 A2 A3 B1 C1 VGND VNB VPB VPWR Y
.ends

* Black-box entry subcircuit for sky130_fd_sc_hd__a41oi_2 abstract view
.subckt sky130_fd_sc_hd__a41oi_2 A1 A2 A3 A4 B1 VGND VNB VPB VPWR Y
.ends

* Black-box entry subcircuit for sky130_fd_sc_hd__a311o_1 abstract view
.subckt sky130_fd_sc_hd__a311o_1 A1 A2 A3 B1 C1 VGND VNB VPB VPWR X
.ends

* Black-box entry subcircuit for sky130_fd_sc_hd__or4_4 abstract view
.subckt sky130_fd_sc_hd__or4_4 A B C D VGND VNB VPB VPWR X
.ends

* Black-box entry subcircuit for sky130_fd_sc_hd__a32oi_4 abstract view
.subckt sky130_fd_sc_hd__a32oi_4 A1 A2 A3 B1 B2 VGND VNB VPB VPWR Y
.ends

* Black-box entry subcircuit for sky130_fd_sc_hd__a21boi_4 abstract view
.subckt sky130_fd_sc_hd__a21boi_4 A1 A2 B1_N VGND VNB VPB VPWR Y
.ends

* Black-box entry subcircuit for sky130_fd_sc_hd__o32ai_2 abstract view
.subckt sky130_fd_sc_hd__o32ai_2 A1 A2 A3 B1 B2 VGND VNB VPB VPWR Y
.ends

* Black-box entry subcircuit for sky130_fd_sc_hd__a31oi_2 abstract view
.subckt sky130_fd_sc_hd__a31oi_2 A1 A2 A3 B1 VGND VNB VPB VPWR Y
.ends

* Black-box entry subcircuit for sky130_fd_sc_hd__o21a_4 abstract view
.subckt sky130_fd_sc_hd__o21a_4 A1 A2 B1 VGND VNB VPB VPWR X
.ends

* Black-box entry subcircuit for sky130_fd_sc_hd__o41ai_4 abstract view
.subckt sky130_fd_sc_hd__o41ai_4 A1 A2 A3 A4 B1 VGND VNB VPB VPWR Y
.ends

* Black-box entry subcircuit for sky130_fd_sc_hd__or3_1 abstract view
.subckt sky130_fd_sc_hd__or3_1 A B C VGND VNB VPB VPWR X
.ends

* Black-box entry subcircuit for sky130_fd_sc_hd__o21bai_1 abstract view
.subckt sky130_fd_sc_hd__o21bai_1 A1 A2 B1_N VGND VNB VPB VPWR Y
.ends

* Black-box entry subcircuit for sky130_fd_sc_hd__a32o_1 abstract view
.subckt sky130_fd_sc_hd__a32o_1 A1 A2 A3 B1 B2 VGND VNB VPB VPWR X
.ends

* Black-box entry subcircuit for sky130_fd_sc_hd__inv_6 abstract view
.subckt sky130_fd_sc_hd__inv_6 A VGND VNB VPB VPWR Y
.ends

* Black-box entry subcircuit for sky130_fd_sc_hd__o221a_4 abstract view
.subckt sky130_fd_sc_hd__o221a_4 A1 A2 B1 B2 C1 VGND VNB VPB VPWR X
.ends

* Black-box entry subcircuit for sky130_fd_sc_hd__o21a_2 abstract view
.subckt sky130_fd_sc_hd__o21a_2 A1 A2 B1 VGND VNB VPB VPWR X
.ends

* Black-box entry subcircuit for sky130_fd_sc_hd__a2bb2oi_1 abstract view
.subckt sky130_fd_sc_hd__a2bb2oi_1 A1_N A2_N B1 B2 VGND VNB VPB VPWR Y
.ends

* Black-box entry subcircuit for sky130_fd_sc_hd__o31ai_4 abstract view
.subckt sky130_fd_sc_hd__o31ai_4 A1 A2 A3 B1 VGND VNB VPB VPWR Y
.ends

* Black-box entry subcircuit for sky130_fd_sc_hd__and3_4 abstract view
.subckt sky130_fd_sc_hd__and3_4 A B C VGND VNB VPB VPWR X
.ends

* Black-box entry subcircuit for sky130_fd_sc_hd__nand3b_4 abstract view
.subckt sky130_fd_sc_hd__nand3b_4 A_N B C VGND VNB VPB VPWR Y
.ends

* Black-box entry subcircuit for sky130_fd_sc_hd__nand2_4 abstract view
.subckt sky130_fd_sc_hd__nand2_4 A B VGND VNB VPB VPWR Y
.ends

* Black-box entry subcircuit for sky130_fd_sc_hd__a2bb2o_4 abstract view
.subckt sky130_fd_sc_hd__a2bb2o_4 A1_N A2_N B1 B2 VGND VNB VPB VPWR X
.ends

* Black-box entry subcircuit for sky130_fd_sc_hd__o2bb2a_1 abstract view
.subckt sky130_fd_sc_hd__o2bb2a_1 A1_N A2_N B1 B2 VGND VNB VPB VPWR X
.ends

* Black-box entry subcircuit for sky130_fd_sc_hd__or3_2 abstract view
.subckt sky130_fd_sc_hd__or3_2 A B C VGND VNB VPB VPWR X
.ends

* Black-box entry subcircuit for sky130_fd_sc_hd__a32oi_2 abstract view
.subckt sky130_fd_sc_hd__a32oi_2 A1 A2 A3 B1 B2 VGND VNB VPB VPWR Y
.ends

* Black-box entry subcircuit for sky130_fd_sc_hd__a221o_1 abstract view
.subckt sky130_fd_sc_hd__a221o_1 A1 A2 B1 B2 C1 VGND VNB VPB VPWR X
.ends

* Black-box entry subcircuit for sky130_fd_sc_hd__a41oi_1 abstract view
.subckt sky130_fd_sc_hd__a41oi_1 A1 A2 A3 A4 B1 VGND VNB VPB VPWR Y
.ends

* Black-box entry subcircuit for sky130_fd_sc_hd__and4_4 abstract view
.subckt sky130_fd_sc_hd__and4_4 A B C D VGND VNB VPB VPWR X
.ends

* Black-box entry subcircuit for sky130_fd_sc_hd__nand4b_1 abstract view
.subckt sky130_fd_sc_hd__nand4b_1 A_N B C D VGND VNB VPB VPWR Y
.ends

* Black-box entry subcircuit for sky130_fd_sc_hd__xnor2_1 abstract view
.subckt sky130_fd_sc_hd__xnor2_1 A B VGND VNB VPB VPWR Y
.ends

* Black-box entry subcircuit for sky130_fd_sc_hd__nor3b_1 abstract view
.subckt sky130_fd_sc_hd__nor3b_1 A B C_N VGND VNB VPB VPWR Y
.ends

* Black-box entry subcircuit for sky130_fd_sc_hd__nand3b_2 abstract view
.subckt sky130_fd_sc_hd__nand3b_2 A_N B C VGND VNB VPB VPWR Y
.ends

* Black-box entry subcircuit for sky130_fd_sc_hd__nor4_2 abstract view
.subckt sky130_fd_sc_hd__nor4_2 A B C D VGND VNB VPB VPWR Y
.ends

* Black-box entry subcircuit for sky130_fd_sc_hd__o41ai_2 abstract view
.subckt sky130_fd_sc_hd__o41ai_2 A1 A2 A3 A4 B1 VGND VNB VPB VPWR Y
.ends

* Black-box entry subcircuit for sky130_fd_sc_hd__o211a_2 abstract view
.subckt sky130_fd_sc_hd__o211a_2 A1 A2 B1 C1 VGND VNB VPB VPWR X
.ends

* Black-box entry subcircuit for sky130_fd_sc_hd__o221a_1 abstract view
.subckt sky130_fd_sc_hd__o221a_1 A1 A2 B1 B2 C1 VGND VNB VPB VPWR X
.ends

* Black-box entry subcircuit for sky130_fd_sc_hd__a221oi_2 abstract view
.subckt sky130_fd_sc_hd__a221oi_2 A1 A2 B1 B2 C1 VGND VNB VPB VPWR Y
.ends

* Black-box entry subcircuit for sky130_fd_sc_hd__a2bb2oi_2 abstract view
.subckt sky130_fd_sc_hd__a2bb2oi_2 A1_N A2_N B1 B2 VGND VNB VPB VPWR Y
.ends

* Black-box entry subcircuit for sky130_fd_sc_hd__and2b_1 abstract view
.subckt sky130_fd_sc_hd__and2b_1 A_N B VGND VNB VPB VPWR X
.ends

.subckt PE VGND VPWR a_in[0] a_in[1] a_in[2] a_in[3] a_in[4] a_in[5] a_in[6] a_in[7]
+ a_out[0] a_out[1] a_out[2] a_out[3] a_out[4] a_out[5] a_out[6] a_out[7] b_in[0]
+ b_in[1] b_in[2] b_in[3] b_in[4] b_in[5] b_in[6] b_in[7] b_out[0] b_out[1] b_out[2]
+ b_out[3] b_out[4] b_out[5] b_out[6] b_out[7] clear_acc clk psum[0] psum[10] psum[11]
+ psum[12] psum[13] psum[14] psum[15] psum[16] psum[17] psum[18] psum[19] psum[1]
+ psum[20] psum[21] psum[22] psum[23] psum[24] psum[25] psum[26] psum[27] psum[28]
+ psum[29] psum[2] psum[30] psum[31] psum[3] psum[4] psum[5] psum[6] psum[7] psum[8]
+ psum[9] reset v_a_in v_a_out v_b_in v_b_out
XFILLER_26_41 VGND VGND VPWR VPWR sky130_fd_sc_hd__fill_1
XFILLER_26_85 VGND VGND VPWR VPWR sky130_fd_sc_hd__fill_2
Xrebuffer7 _0476_ VGND VGND VPWR VPWR net143 sky130_fd_sc_hd__dlygate4sd1_1
XTAP_TAPCELL_ROW_23_194 VGND VPWR sky130_fd_sc_hd__tapvpwrvgnd_1
X_1270_ _0591_ _0593_ _0595_ VGND VGND VPWR VPWR _0597_ sky130_fd_sc_hd__o21ai_1
XFILLER_8_192 VGND VGND VPWR VPWR sky130_fd_sc_hd__decap_4
X_0985_ _0315_ _0316_ _0245_ _0274_ VGND VGND VPWR VPWR _0317_ sky130_fd_sc_hd__o2bb2ai_2
X_1399_ clknet_3_3__leaf_clk _0025_ VGND VGND VPWR VPWR net53 sky130_fd_sc_hd__dfxtp_1
XTAP_TAPCELL_ROW_6_118 VGND VPWR sky130_fd_sc_hd__tapvpwrvgnd_1
Xfanout105 net107 VGND VGND VPWR VPWR net105 sky130_fd_sc_hd__buf_4
Xfanout127 net128 VGND VGND VPWR VPWR net127 sky130_fd_sc_hd__clkbuf_2
Xfanout116 net15 VGND VGND VPWR VPWR net116 sky130_fd_sc_hd__clkbuf_4
XFILLER_10_158 VGND VGND VPWR VPWR sky130_fd_sc_hd__fill_1
Xhold192 net65 VGND VGND VPWR VPWR net328 sky130_fd_sc_hd__dlygate4sd3_1
Xhold181 product_reg\[4\] VGND VGND VPWR VPWR net317 sky130_fd_sc_hd__dlygate4sd3_1
XTAP_TAPCELL_ROW_28_220 VGND VPWR sky130_fd_sc_hd__tapvpwrvgnd_1
XTAP_TAPCELL_ROW_11_142 VGND VPWR sky130_fd_sc_hd__tapvpwrvgnd_1
X_0770_ _0138_ _0139_ VGND VGND VPWR VPWR _0140_ sky130_fd_sc_hd__nand2_1
X_1253_ _0576_ _0578_ _0579_ VGND VGND VPWR VPWR _0580_ sky130_fd_sc_hd__and3_1
X_1322_ _0620_ _0618_ _0616_ _0645_ VGND VGND VPWR VPWR _0647_ sky130_fd_sc_hd__a211oi_1
X_1184_ _0321_ _0377_ _0447_ VGND VGND VPWR VPWR _0513_ sky130_fd_sc_hd__o21ai_4
X_0968_ net131 net103 net147 net199 VGND VGND VPWR VPWR _0300_ sky130_fd_sc_hd__a22oi_4
XTAP_TAPCELL_ROW_34_245 VGND VPWR sky130_fd_sc_hd__tapvpwrvgnd_1
X_0899_ net221 net111 net135 net133 VGND VGND VPWR VPWR _0235_ sky130_fd_sc_hd__a22o_1
XFILLER_15_206 VGND VGND VPWR VPWR sky130_fd_sc_hd__fill_2
XFILLER_2_110 VGND VGND VPWR VPWR sky130_fd_sc_hd__fill_2
X_0822_ _0185_ _0184_ _0070_ VGND VGND VPWR VPWR _0186_ sky130_fd_sc_hd__a21o_1
X_0753_ _0123_ _0124_ VGND VGND VPWR VPWR _0125_ sky130_fd_sc_hd__and2_1
X_1305_ _0629_ _0627_ _0630_ VGND VGND VPWR VPWR _0054_ sky130_fd_sc_hd__a21oi_1
X_1236_ _0558_ net174 net229 VGND VGND VPWR VPWR _0564_ sky130_fd_sc_hd__o21ai_1
X_1098_ net160 _0424_ _0422_ _0426_ VGND VGND VPWR VPWR _0428_ sky130_fd_sc_hd__o211ai_4
X_1167_ _0488_ _0489_ net163 _0479_ VGND VGND VPWR VPWR _0496_ sky130_fd_sc_hd__o211ai_4
XFILLER_20_253 VGND VGND VPWR VPWR sky130_fd_sc_hd__fill_1
XFILLER_18_75 VGND VGND VPWR VPWR sky130_fd_sc_hd__decap_8
XFILLER_11_253 VGND VGND VPWR VPWR sky130_fd_sc_hd__fill_1
XFILLER_34_85 VGND VGND VPWR VPWR sky130_fd_sc_hd__decap_4
XFILLER_38_139 VGND VGND VPWR VPWR sky130_fd_sc_hd__fill_1
XFILLER_22_7 VGND VGND VPWR VPWR sky130_fd_sc_hd__fill_1
X_1021_ _0344_ _0348_ net155 net138 VGND VGND VPWR VPWR _0352_ sky130_fd_sc_hd__o211ai_4
X_0805_ _0157_ _0159_ _0163_ _0164_ VGND VGND VPWR VPWR _0171_ sky130_fd_sc_hd__a22o_1
X_0736_ _0106_ _0103_ _0104_ VGND VGND VPWR VPWR _0110_ sky130_fd_sc_hd__a21oi_4
X_1219_ _0537_ _0538_ _0546_ VGND VGND VPWR VPWR _0547_ sky130_fd_sc_hd__o21bai_2
XFILLER_20_65 VGND VGND VPWR VPWR sky130_fd_sc_hd__decap_3
XFILLER_29_96 VPWR VGND VPWR VGND sky130_ef_sc_hd__decap_12
XFILLER_28_194 VGND VGND VPWR VPWR sky130_fd_sc_hd__fill_2
Xrebuffer39 net176 VGND VGND VPWR VPWR net175 sky130_fd_sc_hd__dlymetal6s4s_1
Xrebuffer17 _0327_ VGND VGND VPWR VPWR net153 sky130_fd_sc_hd__clkbuf_2
Xrebuffer28 _0470_ VGND VGND VPWR VPWR net164 sky130_fd_sc_hd__clkbuf_2
XPHY_EDGE_ROW_16_Left_59 VGND VGND VPWR VPWR sky130_fd_sc_hd__decap_3
X_1004_ net197 net131 net186 net6 _0326_ VGND VGND VPWR VPWR _0335_ sky130_fd_sc_hd__a41o_1
XFILLER_34_197 VGND VGND VPWR VPWR sky130_fd_sc_hd__fill_2
X_0719_ product_reg\[2\] net59 VGND VGND VPWR VPWR _0095_ sky130_fd_sc_hd__nand2_1
XFILLER_25_120 VGND VGND VPWR VPWR sky130_fd_sc_hd__fill_2
XFILLER_15_65 VGND VGND VPWR VPWR sky130_fd_sc_hd__fill_1
Xoutput53 net53 VGND VGND VPWR VPWR psum[24] sky130_fd_sc_hd__buf_2
Xoutput31 net31 VGND VGND VPWR VPWR b_out[2] sky130_fd_sc_hd__buf_2
XFILLER_31_86 VGND VGND VPWR VPWR sky130_fd_sc_hd__decap_3
Xoutput42 net42 VGND VGND VPWR VPWR psum[14] sky130_fd_sc_hd__buf_2
Xoutput64 net64 VGND VGND VPWR VPWR psum[5] sky130_fd_sc_hd__buf_2
XFILLER_16_186 VGND VGND VPWR VPWR sky130_fd_sc_hd__decap_3
XFILLER_16_197 VPWR VGND VPWR VGND sky130_ef_sc_hd__decap_12
XTAP_TAPCELL_ROW_17_170 VGND VPWR sky130_fd_sc_hd__tapvpwrvgnd_1
Xclkbuf_3_6__f_clk clknet_0_clk VGND VGND VPWR VPWR clknet_3_6__leaf_clk sky130_fd_sc_hd__clkbuf_16
Xrebuffer8 _0476_ VGND VGND VPWR VPWR net144 sky130_fd_sc_hd__buf_1
XTAP_TAPCELL_ROW_23_195 VGND VPWR sky130_fd_sc_hd__tapvpwrvgnd_1
X_0984_ _0288_ _0310_ _0311_ VGND VGND VPWR VPWR _0316_ sky130_fd_sc_hd__nand3_2
X_1398_ clknet_3_3__leaf_clk _0024_ VGND VGND VPWR VPWR net52 sky130_fd_sc_hd__dfxtp_1
XTAP_TAPCELL_ROW_6_119 VGND VPWR sky130_fd_sc_hd__tapvpwrvgnd_1
Xfanout128 net12 VGND VGND VPWR VPWR net128 sky130_fd_sc_hd__clkbuf_4
Xfanout106 net107 VGND VGND VPWR VPWR net106 sky130_fd_sc_hd__buf_6
Xfanout117 net15 VGND VGND VPWR VPWR net117 sky130_fd_sc_hd__buf_2
XPHY_EDGE_ROW_19_Left_62 VGND VGND VPWR VPWR sky130_fd_sc_hd__decap_3
XFILLER_12_77 VGND VGND VPWR VPWR sky130_fd_sc_hd__fill_1
Xhold182 product_reg\[2\] VGND VGND VPWR VPWR net318 sky130_fd_sc_hd__dlygate4sd3_1
Xhold193 net67 VGND VGND VPWR VPWR net329 sky130_fd_sc_hd__dlygate4sd3_1
XFILLER_5_185 VGND VGND VPWR VPWR sky130_fd_sc_hd__fill_1
XTAP_TAPCELL_ROW_11_143 VGND VPWR sky130_fd_sc_hd__tapvpwrvgnd_1
X_1252_ net125 net121 net95 net92 VGND VGND VPWR VPWR _0579_ sky130_fd_sc_hd__nand4_4
X_1321_ _0618_ _0620_ _0616_ VGND VGND VPWR VPWR _0646_ sky130_fd_sc_hd__a21oi_1
X_1183_ net169 _0510_ _0509_ VGND VGND VPWR VPWR _0512_ sky130_fd_sc_hd__o21ai_2
XTAP_TAPCELL_ROW_34_246 VGND VPWR sky130_fd_sc_hd__tapvpwrvgnd_1
X_0967_ net106 net129 VGND VGND VPWR VPWR _0299_ sky130_fd_sc_hd__nand2_1
XPHY_EDGE_ROW_12_Right_12 VGND VGND VPWR VPWR sky130_fd_sc_hd__decap_3
X_0898_ net220 net133 net111 net135 VGND VGND VPWR VPWR _0234_ sky130_fd_sc_hd__nand4_1
XTAP_TAPCELL_ROW_2_100 VGND VPWR sky130_fd_sc_hd__tapvpwrvgnd_1
XPHY_EDGE_ROW_21_Right_21 VGND VGND VPWR VPWR sky130_fd_sc_hd__decap_3
XPHY_EDGE_ROW_4_Left_47 VGND VGND VPWR VPWR sky130_fd_sc_hd__decap_3
XFILLER_23_54 VGND VGND VPWR VPWR sky130_fd_sc_hd__fill_2
XPHY_EDGE_ROW_30_Right_30 VGND VGND VPWR VPWR sky130_fd_sc_hd__decap_3
X_0821_ _0183_ _0182_ _0179_ _0180_ VGND VGND VPWR VPWR _0185_ sky130_fd_sc_hd__o211ai_2
X_0752_ product_reg\[6\] net65 VGND VGND VPWR VPWR _0124_ sky130_fd_sc_hd__or2_1
XTAP_TAPCELL_ROW_0_90 VGND VPWR sky130_fd_sc_hd__tapvpwrvgnd_1
X_1166_ _0477_ _0479_ _0486_ _0487_ VGND VGND VPWR VPWR _0495_ sky130_fd_sc_hd__o2bb2ai_2
X_1235_ _0515_ _0512_ _0511_ VGND VGND VPWR VPWR _0563_ sky130_fd_sc_hd__o21a_1
X_1304_ product_reg\[11\] net78 net82 VGND VGND VPWR VPWR _0630_ sky130_fd_sc_hd__o21ai_1
X_1097_ _0354_ net137 _0420_ net172 VGND VGND VPWR VPWR _0427_ sky130_fd_sc_hd__a22oi_4
X_1020_ net138 _0337_ _0349_ VGND VGND VPWR VPWR _0351_ sky130_fd_sc_hd__a21o_4
XFILLER_15_7 VGND VGND VPWR VPWR sky130_fd_sc_hd__fill_2
X_0804_ product_reg\[11\] net39 _0164_ _0163_ _0159_ VGND VGND VPWR VPWR _0170_ sky130_fd_sc_hd__o2111ai_4
X_0735_ net76 net320 net84 _0109_ VGND VGND VPWR VPWR _0004_ sky130_fd_sc_hd__o211a_1
X_1149_ _0424_ net175 _0475_ VGND VGND VPWR VPWR _0478_ sky130_fd_sc_hd__a21oi_4
X_1218_ _0544_ _0545_ VGND VGND VPWR VPWR _0546_ sky130_fd_sc_hd__nand2_1
XPHY_EDGE_ROW_7_Left_50 VGND VGND VPWR VPWR sky130_fd_sc_hd__decap_3
Xrebuffer18 _0327_ VGND VGND VPWR VPWR net154 sky130_fd_sc_hd__buf_8
Xrebuffer29 net130 VGND VGND VPWR VPWR net165 sky130_fd_sc_hd__dlymetal6s2s_1
X_1003_ net129 net103 _0328_ _0331_ VGND VGND VPWR VPWR _0334_ sky130_fd_sc_hd__a22o_1
XFILLER_34_110 VGND VGND VPWR VPWR sky130_fd_sc_hd__decap_3
X_0718_ net77 net294 net83 _0094_ VGND VGND VPWR VPWR _0002_ sky130_fd_sc_hd__o211a_1
XPHY_EDGE_ROW_6_Right_6 VGND VGND VPWR VPWR sky130_fd_sc_hd__decap_3
XFILLER_15_88 VGND VGND VPWR VPWR sky130_fd_sc_hd__decap_3
Xoutput54 net54 VGND VGND VPWR VPWR psum[25] sky130_fd_sc_hd__buf_2
Xoutput65 net65 VGND VGND VPWR VPWR psum[6] sky130_fd_sc_hd__buf_2
XFILLER_0_231 VPWR VGND VPWR VGND sky130_ef_sc_hd__decap_12
XFILLER_0_253 VGND VGND VPWR VPWR sky130_fd_sc_hd__fill_1
Xoutput32 net32 VGND VGND VPWR VPWR b_out[3] sky130_fd_sc_hd__buf_2
Xoutput21 net21 VGND VGND VPWR VPWR a_out[0] sky130_fd_sc_hd__buf_2
XPHY_EDGE_ROW_33_Left_76 VGND VGND VPWR VPWR sky130_fd_sc_hd__decap_3
Xoutput43 net43 VGND VGND VPWR VPWR psum[15] sky130_fd_sc_hd__buf_2
XFILLER_39_235 VGND VGND VPWR VPWR sky130_fd_sc_hd__fill_1
Xrebuffer9 net144 VGND VGND VPWR VPWR net145 sky130_fd_sc_hd__buf_1
XTAP_TAPCELL_ROW_23_196 VGND VPWR sky130_fd_sc_hd__tapvpwrvgnd_1
XFILLER_36_205 VGND VGND VPWR VPWR sky130_fd_sc_hd__fill_1
X_0983_ _0308_ _0312_ _0313_ _0287_ VGND VGND VPWR VPWR _0315_ sky130_fd_sc_hd__o211ai_2
Xfanout118 net120 VGND VGND VPWR VPWR net118 sky130_fd_sc_hd__buf_4
Xfanout129 net130 VGND VGND VPWR VPWR net129 sky130_fd_sc_hd__buf_6
Xfanout107 net4 VGND VGND VPWR VPWR net107 sky130_fd_sc_hd__clkbuf_4
X_1397_ clknet_3_3__leaf_clk _0023_ VGND VGND VPWR VPWR net51 sky130_fd_sc_hd__dfxtp_1
Xhold172 net56 VGND VGND VPWR VPWR net308 sky130_fd_sc_hd__dlygate4sd3_1
Xhold194 product_reg\[10\] VGND VGND VPWR VPWR net330 sky130_fd_sc_hd__dlygate4sd3_1
Xhold183 product_reg\[14\] VGND VGND VPWR VPWR net319 sky130_fd_sc_hd__dlygate4sd3_1
X_1320_ _0643_ _0644_ VGND VGND VPWR VPWR _0645_ sky130_fd_sc_hd__nor2_1
X_1251_ net121 net95 net92 net125 VGND VGND VPWR VPWR _0578_ sky130_fd_sc_hd__a22o_2
X_1182_ _0435_ net146 _0505_ _0507_ _0508_ VGND VGND VPWR VPWR _0511_ sky130_fd_sc_hd__o2111ai_4
XPHY_EDGE_ROW_20_Left_63 VGND VGND VPWR VPWR sky130_fd_sc_hd__decap_3
XTAP_TAPCELL_ROW_34_247 VGND VPWR sky130_fd_sc_hd__tapvpwrvgnd_1
XTAP_TAPCELL_ROW_42_280 VGND VPWR sky130_fd_sc_hd__tapvpwrvgnd_1
X_0966_ _0264_ _0265_ _0267_ VGND VGND VPWR VPWR _0298_ sky130_fd_sc_hd__o21a_1
X_0897_ net324 net78 _0232_ _0233_ VGND VGND VPWR VPWR _0043_ sky130_fd_sc_hd__o22a_1
XTAP_TAPCELL_ROW_2_101 VGND VPWR sky130_fd_sc_hd__tapvpwrvgnd_1
XTAP_TAPCELL_ROW_25_203 VGND VPWR sky130_fd_sc_hd__tapvpwrvgnd_1
XFILLER_23_33 VGND VGND VPWR VPWR sky130_fd_sc_hd__decap_8
XFILLER_23_99 VPWR VGND VPWR VGND sky130_ef_sc_hd__decap_12
X_0820_ _0179_ _0180_ net290 _0183_ VGND VGND VPWR VPWR _0184_ sky130_fd_sc_hd__a211o_1
X_0751_ product_reg\[6\] net65 VGND VGND VPWR VPWR _0123_ sky130_fd_sc_hd__nand2_1
XTAP_TAPCELL_ROW_0_91 VGND VPWR sky130_fd_sc_hd__tapvpwrvgnd_1
X_1303_ _0603_ _0628_ _0085_ VGND VGND VPWR VPWR _0629_ sky130_fd_sc_hd__a21oi_2
X_1096_ _0337_ _0350_ _0338_ VGND VGND VPWR VPWR _0426_ sky130_fd_sc_hd__a21o_1
X_1165_ net161 _0479_ _0490_ VGND VGND VPWR VPWR _0494_ sky130_fd_sc_hd__a21oi_4
X_1234_ _0560_ _0558_ VGND VGND VPWR VPWR _0562_ sky130_fd_sc_hd__nor2_4
X_0949_ _0279_ _0280_ _0261_ VGND VGND VPWR VPWR _0282_ sky130_fd_sc_hd__a21o_1
X_0803_ product_reg\[9\] net68 _0168_ _0153_ VGND VGND VPWR VPWR _0169_ sky130_fd_sc_hd__o211ai_4
X_0734_ _0107_ _0108_ net76 VGND VGND VPWR VPWR _0109_ sky130_fd_sc_hd__o21ai_1
XFILLER_29_108 VGND VGND VPWR VPWR sky130_fd_sc_hd__decap_4
X_1079_ net126 net103 net123 net105 VGND VGND VPWR VPWR _0409_ sky130_fd_sc_hd__a22oi_4
X_1148_ _0473_ _0472_ _0476_ VGND VGND VPWR VPWR _0477_ sky130_fd_sc_hd__o21ai_4
X_1217_ _0542_ _0543_ net110 net114 VGND VGND VPWR VPWR _0545_ sky130_fd_sc_hd__nand4_1
Xrebuffer19 _0337_ VGND VGND VPWR VPWR net155 sky130_fd_sc_hd__buf_1
X_1002_ net153 _0330_ _0326_ VGND VGND VPWR VPWR _0333_ sky130_fd_sc_hd__o21bai_2
X_0717_ _0092_ _0093_ net76 VGND VGND VPWR VPWR _0094_ sky130_fd_sc_hd__o21ai_1
XFILLER_15_12 VGND VGND VPWR VPWR sky130_fd_sc_hd__fill_1
XFILLER_31_66 VPWR VGND VPWR VGND sky130_ef_sc_hd__decap_12
Xoutput55 net55 VGND VGND VPWR VPWR psum[26] sky130_fd_sc_hd__buf_2
Xoutput44 net44 VGND VGND VPWR VPWR psum[16] sky130_fd_sc_hd__buf_2
Xoutput66 net66 VGND VGND VPWR VPWR psum[7] sky130_fd_sc_hd__buf_2
XFILLER_0_243 VGND VGND VPWR VPWR sky130_fd_sc_hd__decap_8
Xoutput22 net22 VGND VGND VPWR VPWR a_out[1] sky130_fd_sc_hd__buf_2
Xoutput33 net33 VGND VGND VPWR VPWR b_out[4] sky130_fd_sc_hd__buf_2
XFILLER_31_158 VGND VGND VPWR VPWR sky130_fd_sc_hd__decap_8
XFILLER_31_169 VPWR VGND VPWR VGND sky130_ef_sc_hd__decap_12
XFILLER_22_158 VGND VGND VPWR VPWR sky130_fd_sc_hd__fill_1
XFILLER_26_11 VGND VGND VPWR VPWR sky130_fd_sc_hd__decap_4
XFILLER_13_169 VGND VGND VPWR VPWR sky130_fd_sc_hd__fill_2
XTAP_TAPCELL_ROW_23_197 VGND VPWR sky130_fd_sc_hd__tapvpwrvgnd_1
XFILLER_21_191 VPWR VGND VPWR VGND sky130_ef_sc_hd__decap_12
X_0982_ _0308_ _0312_ _0313_ _0287_ VGND VGND VPWR VPWR _0314_ sky130_fd_sc_hd__o211a_1
XFILLER_8_151 VGND VGND VPWR VPWR sky130_fd_sc_hd__fill_2
XTAP_TAPCELL_ROW_14_153 VGND VPWR sky130_fd_sc_hd__tapvpwrvgnd_1
Xfanout108 net110 VGND VGND VPWR VPWR net108 sky130_fd_sc_hd__buf_4
Xfanout119 net120 VGND VGND VPWR VPWR net119 sky130_fd_sc_hd__clkbuf_4
X_1396_ clknet_3_6__leaf_clk _0022_ VGND VGND VPWR VPWR net50 sky130_fd_sc_hd__dfxtp_1
Xhold195 net38 VGND VGND VPWR VPWR net331 sky130_fd_sc_hd__dlygate4sd3_1
Xhold173 product_reg\[8\] VGND VGND VPWR VPWR net309 sky130_fd_sc_hd__dlygate4sd3_1
Xhold184 net62 VGND VGND VPWR VPWR net320 sky130_fd_sc_hd__dlygate4sd3_1
XFILLER_37_65 VGND VGND VPWR VPWR sky130_fd_sc_hd__fill_1
XFILLER_37_54 VGND VGND VPWR VPWR sky130_fd_sc_hd__fill_2
XFILLER_18_228 VGND VGND VPWR VPWR sky130_fd_sc_hd__fill_2
X_1250_ net121 net95 net92 net125 VGND VGND VPWR VPWR _0577_ sky130_fd_sc_hd__a22oi_2
X_1181_ _0435_ net146 _0508_ _0507_ VGND VGND VPWR VPWR _0510_ sky130_fd_sc_hd__o211ai_2
XTAP_TAPCELL_ROW_42_281 VGND VPWR sky130_fd_sc_hd__tapvpwrvgnd_1
XFILLER_32_253 VGND VGND VPWR VPWR sky130_fd_sc_hd__fill_1
X_0965_ _0264_ _0265_ _0267_ VGND VGND VPWR VPWR _0297_ sky130_fd_sc_hd__o21ai_1
X_0896_ net222 net135 net85 VGND VGND VPWR VPWR _0233_ sky130_fd_sc_hd__and3_1
XTAP_TAPCELL_ROW_2_102 VGND VPWR sky130_fd_sc_hd__tapvpwrvgnd_1
XTAP_TAPCELL_ROW_25_204 VGND VPWR sky130_fd_sc_hd__tapvpwrvgnd_1
X_1379_ clknet_3_7__leaf_clk _0005_ VGND VGND VPWR VPWR net63 sky130_fd_sc_hd__dfxtp_1
XFILLER_23_253 VGND VGND VPWR VPWR sky130_fd_sc_hd__fill_1
XFILLER_14_253 VGND VGND VPWR VPWR sky130_fd_sc_hd__fill_1
Xfanout90 net91 VGND VGND VPWR VPWR net90 sky130_fd_sc_hd__buf_8
X_0750_ _0070_ _0072_ net17 net18 _0122_ VGND VGND VPWR VPWR _0006_ sky130_fd_sc_hd__a2111oi_1
XTAP_TAPCELL_ROW_0_92 VGND VPWR sky130_fd_sc_hd__tapvpwrvgnd_1
X_1233_ net151 _0555_ _0556_ _0557_ VGND VGND VPWR VPWR _0561_ sky130_fd_sc_hd__nand4_4
X_1302_ _0599_ _0626_ VGND VGND VPWR VPWR _0628_ sky130_fd_sc_hd__nor2_1
X_1095_ _0413_ _0415_ _0406_ net228 VGND VGND VPWR VPWR _0425_ sky130_fd_sc_hd__o211ai_1
X_1164_ _0486_ _0487_ net143 _0475_ net142 VGND VGND VPWR VPWR _0493_ sky130_fd_sc_hd__o221ai_4
X_0948_ _0261_ _0279_ _0280_ VGND VGND VPWR VPWR _0281_ sky130_fd_sc_hd__nand3_2
X_0879_ _0196_ net57 net58 _0222_ VGND VGND VPWR VPWR _0228_ sky130_fd_sc_hd__nand4_4
X_0802_ _0151_ _0152_ _0157_ _0158_ VGND VGND VPWR VPWR _0168_ sky130_fd_sc_hd__and4_1
X_0733_ _0103_ _0105_ _0106_ VGND VGND VPWR VPWR _0108_ sky130_fd_sc_hd__and3_1
X_1216_ net108 net114 _0542_ _0543_ VGND VGND VPWR VPWR _0544_ sky130_fd_sc_hd__a22o_1
X_1147_ _0419_ _0407_ _0405_ VGND VGND VPWR VPWR _0476_ sky130_fd_sc_hd__a21oi_4
X_1078_ net108 net119 VGND VGND VPWR VPWR _0408_ sky130_fd_sc_hd__nand2_2
XFILLER_20_57 VGND VGND VPWR VPWR sky130_fd_sc_hd__decap_8
XFILLER_3_252 VGND VGND VPWR VPWR sky130_fd_sc_hd__fill_2
XFILLER_10_90 VGND VGND VPWR VPWR sky130_fd_sc_hd__fill_1
X_1001_ _0074_ _0076_ _0328_ _0331_ VGND VGND VPWR VPWR _0332_ sky130_fd_sc_hd__o211ai_4
XFILLER_19_164 VGND VGND VPWR VPWR sky130_fd_sc_hd__decap_4
XFILLER_34_145 VGND VGND VPWR VPWR sky130_fd_sc_hd__fill_2
X_0716_ _0090_ _0091_ product_reg\[0\] net37 VGND VGND VPWR VPWR _0093_ sky130_fd_sc_hd__and4_1
XFILLER_15_57 VGND VGND VPWR VPWR sky130_fd_sc_hd__decap_8
XFILLER_25_189 VGND VGND VPWR VPWR sky130_fd_sc_hd__decap_4
Xoutput23 net23 VGND VGND VPWR VPWR a_out[2] sky130_fd_sc_hd__buf_2
Xoutput34 net34 VGND VGND VPWR VPWR b_out[5] sky130_fd_sc_hd__buf_2
XFILLER_31_78 VGND VGND VPWR VPWR sky130_fd_sc_hd__decap_8
Xoutput67 net67 VGND VGND VPWR VPWR psum[8] sky130_fd_sc_hd__buf_2
Xoutput45 net45 VGND VGND VPWR VPWR psum[17] sky130_fd_sc_hd__buf_2
Xoutput56 net56 VGND VGND VPWR VPWR psum[27] sky130_fd_sc_hd__buf_2
XFILLER_31_148 VGND VGND VPWR VPWR sky130_fd_sc_hd__decap_4
XFILLER_11_3 VGND VGND VPWR VPWR sky130_fd_sc_hd__fill_2
XFILLER_26_23 VGND VGND VPWR VPWR sky130_fd_sc_hd__decap_4
XTAP_TAPCELL_ROW_8_130 VGND VPWR sky130_fd_sc_hd__tapvpwrvgnd_1
X_0981_ _0293_ _0294_ _0307_ _0308_ VGND VGND VPWR VPWR _0313_ sky130_fd_sc_hd__o2bb2ai_2
XTAP_TAPCELL_ROW_14_154 VGND VPWR sky130_fd_sc_hd__tapvpwrvgnd_1
X_1395_ clknet_3_6__leaf_clk _0021_ VGND VGND VPWR VPWR net49 sky130_fd_sc_hd__dfxtp_1
Xfanout109 net110 VGND VGND VPWR VPWR net109 sky130_fd_sc_hd__buf_2
XTAP_TAPCELL_ROW_37_257 VGND VPWR sky130_fd_sc_hd__tapvpwrvgnd_1
Xhold174 net51 VGND VGND VPWR VPWR net310 sky130_fd_sc_hd__dlygate4sd3_1
Xhold185 net59 VGND VGND VPWR VPWR net321 sky130_fd_sc_hd__dlygate4sd3_1
Xhold196 net47 VGND VGND VPWR VPWR net332 sky130_fd_sc_hd__dlygate4sd3_1
XFILLER_5_166 VGND VGND VPWR VPWR sky130_fd_sc_hd__fill_2
X_1180_ _0439_ _0366_ _0504_ _0506_ net139 VGND VGND VPWR VPWR _0509_ sky130_fd_sc_hd__o221ai_4
XTAP_TAPCELL_ROW_42_282 VGND VPWR sky130_fd_sc_hd__tapvpwrvgnd_1
X_0964_ _0264_ _0267_ VGND VGND VPWR VPWR _0296_ sky130_fd_sc_hd__nand2_1
X_0895_ net20 net19 net79 VGND VGND VPWR VPWR _0232_ sky130_fd_sc_hd__a21oi_4
XTAP_TAPCELL_ROW_2_103 VGND VPWR sky130_fd_sc_hd__tapvpwrvgnd_1
X_1378_ clknet_3_7__leaf_clk _0004_ VGND VGND VPWR VPWR net62 sky130_fd_sc_hd__dfxtp_1
XTAP_TAPCELL_ROW_25_205 VGND VPWR sky130_fd_sc_hd__tapvpwrvgnd_1
Xfanout80 _0083_ VGND VGND VPWR VPWR net80 sky130_fd_sc_hd__clkbuf_2
Xfanout91 net9 VGND VGND VPWR VPWR net91 sky130_fd_sc_hd__buf_6
XTAP_TAPCELL_ROW_0_93 VGND VPWR sky130_fd_sc_hd__tapvpwrvgnd_1
X_1232_ _0556_ _0555_ net151 _0557_ VGND VGND VPWR VPWR _0560_ sky130_fd_sc_hd__and4_1
X_1301_ _0599_ _0602_ _0626_ VGND VGND VPWR VPWR _0627_ sky130_fd_sc_hd__o21ai_1
X_1094_ _0413_ _0415_ net209 VGND VGND VPWR VPWR _0424_ sky130_fd_sc_hd__o21ai_2
X_1163_ _0486_ _0487_ _0476_ _0475_ VGND VGND VPWR VPWR _0492_ sky130_fd_sc_hd__o22ai_1
X_0947_ _0272_ _0273_ _0277_ VGND VGND VPWR VPWR _0280_ sky130_fd_sc_hd__nand3_1
X_0878_ _0196_ net57 net58 _0222_ VGND VGND VPWR VPWR _0227_ sky130_fd_sc_hd__and4_1
XFILLER_11_235 VGND VGND VPWR VPWR sky130_fd_sc_hd__fill_2
XFILLER_34_45 VGND VGND VPWR VPWR sky130_fd_sc_hd__fill_1
XFILLER_34_89 VGND VGND VPWR VPWR sky130_fd_sc_hd__fill_1
Xclkload0 clknet_3_0__leaf_clk VGND VGND VPWR VPWR clkload0/Y sky130_fd_sc_hd__bufinv_16
X_0801_ product_reg\[11\] net39 _0166_ VGND VGND VPWR VPWR _0167_ sky130_fd_sc_hd__a21oi_1
X_0732_ _0105_ _0106_ net283 VGND VGND VPWR VPWR _0107_ sky130_fd_sc_hd__a21oi_1
X_1146_ _0467_ _0471_ _0474_ VGND VGND VPWR VPWR _0475_ sky130_fd_sc_hd__o21ai_4
X_1215_ _0073_ _0079_ _0451_ _0452_ _0454_ VGND VGND VPWR VPWR _0543_ sky130_fd_sc_hd__o221ai_4
X_1077_ _0394_ _0400_ _0401_ VGND VGND VPWR VPWR _0407_ sky130_fd_sc_hd__nand3_4
XFILLER_20_25 VGND VGND VPWR VPWR sky130_fd_sc_hd__decap_3
X_1000_ net88 net131 net185 net147 VGND VGND VPWR VPWR _0331_ sky130_fd_sc_hd__nand4_4
X_0715_ product_reg\[0\] net37 _0090_ _0091_ VGND VGND VPWR VPWR _0092_ sky130_fd_sc_hd__a22oi_1
X_1129_ _0452_ _0457_ VGND VGND VPWR VPWR _0458_ sky130_fd_sc_hd__nor2_2
Xoutput57 net57 VGND VGND VPWR VPWR psum[28] sky130_fd_sc_hd__buf_2
Xoutput46 net46 VGND VGND VPWR VPWR psum[18] sky130_fd_sc_hd__buf_2
Xoutput24 net24 VGND VGND VPWR VPWR a_out[3] sky130_fd_sc_hd__buf_2
Xoutput35 net35 VGND VGND VPWR VPWR b_out[6] sky130_fd_sc_hd__buf_2
XFILLER_31_57 VGND VGND VPWR VPWR sky130_fd_sc_hd__decap_6
Xoutput68 net68 VGND VGND VPWR VPWR psum[9] sky130_fd_sc_hd__buf_2
XFILLER_0_223 VGND VGND VPWR VPWR sky130_fd_sc_hd__fill_1
XFILLER_16_113 VGND VGND VPWR VPWR sky130_fd_sc_hd__fill_2
XPHY_EDGE_ROW_19_Right_19 VGND VGND VPWR VPWR sky130_fd_sc_hd__decap_3
Xclkbuf_3_1__f_clk clknet_0_clk VGND VGND VPWR VPWR clknet_3_1__leaf_clk sky130_fd_sc_hd__clkbuf_16
XPHY_EDGE_ROW_28_Right_28 VGND VGND VPWR VPWR sky130_fd_sc_hd__decap_3
XPHY_EDGE_ROW_37_Right_37 VGND VGND VPWR VPWR sky130_fd_sc_hd__decap_3
XFILLER_13_138 VGND VGND VPWR VPWR sky130_fd_sc_hd__decap_4
XFILLER_42_78 VGND VGND VPWR VPWR sky130_fd_sc_hd__fill_1
X_0980_ _0306_ _0298_ _0295_ VGND VGND VPWR VPWR _0312_ sky130_fd_sc_hd__a21o_1
XTAP_TAPCELL_ROW_14_155 VGND VPWR sky130_fd_sc_hd__tapvpwrvgnd_1
X_1394_ clknet_3_6__leaf_clk _0020_ VGND VGND VPWR VPWR net47 sky130_fd_sc_hd__dfxtp_1
XTAP_TAPCELL_ROW_37_258 VGND VPWR sky130_fd_sc_hd__tapvpwrvgnd_1
XFILLER_35_230 VGND VGND VPWR VPWR sky130_fd_sc_hd__fill_1
XFILLER_10_108 VGND VGND VPWR VPWR sky130_fd_sc_hd__fill_2
Xhold186 net37 VGND VGND VPWR VPWR net322 sky130_fd_sc_hd__dlygate4sd3_1
Xhold197 net49 VGND VGND VPWR VPWR net333 sky130_fd_sc_hd__dlygate4sd3_1
Xhold175 product_reg\[6\] VGND VGND VPWR VPWR net311 sky130_fd_sc_hd__dlygate4sd3_1
XTAP_TAPCELL_ROW_42_283 VGND VPWR sky130_fd_sc_hd__tapvpwrvgnd_1
X_0963_ _0293_ _0294_ VGND VGND VPWR VPWR _0295_ sky130_fd_sc_hd__nand2_2
X_0894_ _0080_ net79 VGND VGND VPWR VPWR _0042_ sky130_fd_sc_hd__nor2_1
X_1377_ clknet_3_7__leaf_clk _0003_ VGND VGND VPWR VPWR net59 sky130_fd_sc_hd__dfxtp_1
XTAP_TAPCELL_ROW_25_206 VGND VPWR sky130_fd_sc_hd__tapvpwrvgnd_1
Xfanout92 net94 VGND VGND VPWR VPWR net92 sky130_fd_sc_hd__buf_12
Xfanout81 net82 VGND VGND VPWR VPWR net81 sky130_fd_sc_hd__buf_2
XPHY_EDGE_ROW_24_Left_67 VGND VGND VPWR VPWR sky130_fd_sc_hd__decap_3
XTAP_TAPCELL_ROW_0_94 VGND VPWR sky130_fd_sc_hd__tapvpwrvgnd_1
X_1162_ _0477_ _0479_ _0488_ _0489_ VGND VGND VPWR VPWR _0491_ sky130_fd_sc_hd__o2bb2ai_2
X_1231_ _0556_ _0555_ _0557_ net151 VGND VGND VPWR VPWR _0559_ sky130_fd_sc_hd__a22o_4
X_1300_ _0624_ _0625_ VGND VGND VPWR VPWR _0626_ sky130_fd_sc_hd__nand2b_1
X_1093_ _0414_ _0416_ _0404_ _0394_ VGND VGND VPWR VPWR _0423_ sky130_fd_sc_hd__a22oi_2
X_0877_ net57 _0224_ _0225_ net81 VGND VGND VPWR VPWR _0029_ sky130_fd_sc_hd__o211a_1
X_0946_ _0272_ _0273_ _0277_ VGND VGND VPWR VPWR _0279_ sky130_fd_sc_hd__a21o_1
X_1429_ clknet_3_1__leaf_clk _0055_ VGND VGND VPWR VPWR product_reg\[12\] sky130_fd_sc_hd__dfxtp_1
Xclkload1 clknet_3_1__leaf_clk VGND VGND VPWR VPWR clkload1/Y sky130_fd_sc_hd__clkinv_4
XFILLER_6_251 VGND VGND VPWR VPWR sky130_fd_sc_hd__fill_1
X_0731_ product_reg\[3\] net62 VGND VGND VPWR VPWR _0106_ sky130_fd_sc_hd__or2_4
X_0800_ _0157_ net38 product_reg\[10\] VGND VGND VPWR VPWR _0166_ sky130_fd_sc_hd__and3_1
XFILLER_37_100 VPWR VGND VPWR VGND sky130_ef_sc_hd__decap_12
X_1145_ _0455_ _0458_ _0467_ _0469_ VGND VGND VPWR VPWR _0474_ sky130_fd_sc_hd__o22ai_4
XFILLER_1_94 VGND VGND VPWR VPWR sky130_fd_sc_hd__fill_1
X_1214_ _0540_ net116 net105 _0453_ VGND VGND VPWR VPWR _0542_ sky130_fd_sc_hd__nand4_1
X_1076_ _0403_ net224 _0393_ _0402_ VGND VGND VPWR VPWR _0406_ sky130_fd_sc_hd__o211ai_4
X_0929_ _0246_ _0248_ _0247_ VGND VGND VPWR VPWR _0262_ sky130_fd_sc_hd__o21ai_2
XFILLER_29_46 VGND VGND VPWR VPWR sky130_fd_sc_hd__decap_6
XFILLER_29_57 VGND VGND VPWR VPWR sky130_fd_sc_hd__fill_1
XFILLER_6_39 VGND VGND VPWR VPWR sky130_fd_sc_hd__fill_1
X_0714_ net289 net286 VGND VGND VPWR VPWR _0091_ sky130_fd_sc_hd__nand2_1
XPHY_EDGE_ROW_27_Left_70 VGND VGND VPWR VPWR sky130_fd_sc_hd__decap_3
X_1128_ _0454_ net118 net107 VGND VGND VPWR VPWR _0457_ sky130_fd_sc_hd__nand3_2
XPHY_EDGE_ROW_11_Left_54 VGND VGND VPWR VPWR sky130_fd_sc_hd__decap_3
X_1059_ _0385_ _0386_ net136 net115 VGND VGND VPWR VPWR _0389_ sky130_fd_sc_hd__and4_1
XFILLER_25_103 VGND VGND VPWR VPWR sky130_fd_sc_hd__decap_3
XFILLER_25_169 VGND VGND VPWR VPWR sky130_fd_sc_hd__fill_1
XFILLER_40_139 VGND VGND VPWR VPWR sky130_fd_sc_hd__fill_1
Xoutput58 net58 VGND VGND VPWR VPWR psum[29] sky130_fd_sc_hd__buf_2
Xoutput47 net47 VGND VGND VPWR VPWR psum[19] sky130_fd_sc_hd__buf_2
Xoutput25 net25 VGND VGND VPWR VPWR a_out[4] sky130_fd_sc_hd__buf_2
Xoutput69 net69 VGND VGND VPWR VPWR v_a_out sky130_fd_sc_hd__buf_2
Xoutput36 net36 VGND VGND VPWR VPWR b_out[7] sky130_fd_sc_hd__buf_2
XFILLER_16_169 VGND VGND VPWR VPWR sky130_fd_sc_hd__fill_1
XFILLER_31_139 VGND VGND VPWR VPWR sky130_fd_sc_hd__fill_2
XFILLER_22_139 VGND VGND VPWR VPWR sky130_fd_sc_hd__fill_1
XFILLER_21_161 VGND VGND VPWR VPWR sky130_fd_sc_hd__decap_4
XTAP_TAPCELL_ROW_14_156 VGND VPWR sky130_fd_sc_hd__tapvpwrvgnd_1
X_1393_ clknet_3_7__leaf_clk _0019_ VGND VGND VPWR VPWR net46 sky130_fd_sc_hd__dfxtp_1
XTAP_TAPCELL_ROW_37_259 VGND VPWR sky130_fd_sc_hd__tapvpwrvgnd_1
Xhold187 _0087_ VGND VGND VPWR VPWR net323 sky130_fd_sc_hd__dlygate4sd3_1
Xhold198 net54 VGND VGND VPWR VPWR net334 sky130_fd_sc_hd__dlygate4sd3_1
XTAP_TAPCELL_ROW_5_113 VGND VPWR sky130_fd_sc_hd__tapvpwrvgnd_1
Xhold176 product_reg\[12\] VGND VGND VPWR VPWR net312 sky130_fd_sc_hd__dlygate4sd3_1
XFILLER_37_57 VGND VGND VPWR VPWR sky130_fd_sc_hd__decap_8
XFILLER_26_253 VGND VGND VPWR VPWR sky130_fd_sc_hd__fill_1
XFILLER_17_253 VGND VGND VPWR VPWR sky130_fd_sc_hd__fill_1
XFILLER_27_90 VGND VGND VPWR VPWR sky130_fd_sc_hd__fill_2
XTAP_TAPCELL_ROW_42_284 VGND VPWR sky130_fd_sc_hd__tapvpwrvgnd_1
X_0962_ _0292_ net119 net136 _0290_ VGND VGND VPWR VPWR _0294_ sky130_fd_sc_hd__nand4_2
X_0893_ net217 net86 VGND VGND VPWR VPWR _0041_ sky130_fd_sc_hd__and2_1
XFILLER_4_83 VGND VGND VPWR VPWR sky130_fd_sc_hd__fill_1
X_1376_ clknet_3_7__leaf_clk _0002_ VGND VGND VPWR VPWR net48 sky130_fd_sc_hd__dfxtp_2
XTAP_TAPCELL_ROW_33_240 VGND VPWR sky130_fd_sc_hd__tapvpwrvgnd_1
XFILLER_2_138 VGND VGND VPWR VPWR sky130_fd_sc_hd__fill_2
XFILLER_14_234 VGND VGND VPWR VPWR sky130_fd_sc_hd__fill_1
XFILLER_14_245 VGND VGND VPWR VPWR sky130_fd_sc_hd__decap_3
Xfanout82 net86 VGND VGND VPWR VPWR net82 sky130_fd_sc_hd__clkbuf_2
Xfanout71 net72 VGND VGND VPWR VPWR net71 sky130_fd_sc_hd__buf_8
Xfanout93 net94 VGND VGND VPWR VPWR net93 sky130_fd_sc_hd__clkbuf_2
XFILLER_36_7 VGND VGND VPWR VPWR sky130_fd_sc_hd__decap_8
XFILLER_1_160 VGND VGND VPWR VPWR sky130_fd_sc_hd__fill_1
X_1092_ _0406_ _0407_ _0417_ _0418_ VGND VGND VPWR VPWR _0422_ sky130_fd_sc_hd__o2bb2ai_1
X_1161_ _0486_ _0487_ VGND VGND VPWR VPWR _0490_ sky130_fd_sc_hd__nor2_1
X_1230_ _0555_ _0556_ net200 net151 VGND VGND VPWR VPWR _0558_ sky130_fd_sc_hd__a22oi_4
X_0876_ _0195_ net302 net57 _0193_ _0223_ VGND VGND VPWR VPWR _0226_ sky130_fd_sc_hd__o2111a_1
X_0945_ _0275_ _0276_ VGND VGND VPWR VPWR _0278_ sky130_fd_sc_hd__or2_1
X_1428_ clknet_3_1__leaf_clk _0054_ VGND VGND VPWR VPWR product_reg\[11\] sky130_fd_sc_hd__dfxtp_1
XPHY_EDGE_ROW_41_Left_84 VGND VGND VPWR VPWR sky130_fd_sc_hd__decap_3
X_1359_ _0673_ _0674_ _0681_ VGND VGND VPWR VPWR _0682_ sky130_fd_sc_hd__nand3_2
Xclkload2 clknet_3_2__leaf_clk VGND VGND VPWR VPWR clkload2/X sky130_fd_sc_hd__clkbuf_4
X_0730_ product_reg\[3\] net62 VGND VGND VPWR VPWR _0105_ sky130_fd_sc_hd__nand2_1
X_1213_ _0540_ net105 _0453_ net116 VGND VGND VPWR VPWR _0541_ sky130_fd_sc_hd__and4_1
XFILLER_37_167 VGND VGND VPWR VPWR sky130_fd_sc_hd__fill_1
X_1144_ _0455_ _0458_ _0468_ _0470_ VGND VGND VPWR VPWR _0473_ sky130_fd_sc_hd__a2bb2oi_4
X_1075_ net193 net213 net188 _0402_ VGND VGND VPWR VPWR _0405_ sky130_fd_sc_hd__o211a_4
X_0859_ net52 net298 net74 net53 VGND VGND VPWR VPWR _0213_ sky130_fd_sc_hd__a31o_1
X_0928_ _0245_ _0253_ _0255_ VGND VGND VPWR VPWR _0261_ sky130_fd_sc_hd__o21ai_1
XFILLER_3_200 VGND VGND VPWR VPWR sky130_fd_sc_hd__fill_1
X_0713_ net288 net284 VGND VGND VPWR VPWR _0090_ sky130_fd_sc_hd__or2_1
X_1127_ _0453_ _0454_ _0073_ _0078_ VGND VGND VPWR VPWR _0456_ sky130_fd_sc_hd__o2bb2ai_2
X_1058_ _0385_ _0386_ _0075_ net87 VGND VGND VPWR VPWR _0388_ sky130_fd_sc_hd__o2bb2a_2
XFILLER_31_15 VGND VGND VPWR VPWR sky130_fd_sc_hd__decap_8
Xoutput48 net285 VGND VGND VPWR VPWR psum[1] sky130_fd_sc_hd__buf_6
Xoutput37 net37 VGND VGND VPWR VPWR psum[0] sky130_fd_sc_hd__buf_2
XPHY_EDGE_ROW_1_Right_1 VGND VGND VPWR VPWR sky130_fd_sc_hd__decap_3
Xoutput26 net26 VGND VGND VPWR VPWR a_out[5] sky130_fd_sc_hd__buf_2
Xoutput59 net59 VGND VGND VPWR VPWR psum[2] sky130_fd_sc_hd__buf_2
XFILLER_24_192 VGND VGND VPWR VPWR sky130_fd_sc_hd__decap_4
XFILLER_31_118 VPWR VGND VPWR VGND sky130_ef_sc_hd__decap_12
XFILLER_30_195 VGND VGND VPWR VPWR sky130_fd_sc_hd__fill_1
XFILLER_42_14 VPWR VGND VPWR VGND sky130_ef_sc_hd__decap_12
XTAP_TAPCELL_ROW_14_157 VGND VPWR sky130_fd_sc_hd__tapvpwrvgnd_1
XTAP_TAPCELL_ROW_22_190 VGND VPWR sky130_fd_sc_hd__tapvpwrvgnd_1
X_1392_ clknet_3_6__leaf_clk _0018_ VGND VGND VPWR VPWR net45 sky130_fd_sc_hd__dfxtp_1
XTAP_TAPCELL_ROW_5_114 VGND VPWR sky130_fd_sc_hd__tapvpwrvgnd_1
Xhold177 product_reg\[13\] VGND VGND VPWR VPWR net313 sky130_fd_sc_hd__dlygate4sd3_1
Xhold188 product_reg\[0\] VGND VGND VPWR VPWR net324 sky130_fd_sc_hd__dlygate4sd3_1
Xhold199 net42 VGND VGND VPWR VPWR net335 sky130_fd_sc_hd__dlygate4sd3_1
XTAP_TAPCELL_ROW_28_216 VGND VPWR sky130_fd_sc_hd__tapvpwrvgnd_1
XFILLER_17_221 VGND VGND VPWR VPWR sky130_fd_sc_hd__decap_3
X_0961_ _0075_ _0078_ _0289_ _0291_ VGND VGND VPWR VPWR _0293_ sky130_fd_sc_hd__o22ai_2
XTAP_TAPCELL_ROW_42_285 VGND VPWR sky130_fd_sc_hd__tapvpwrvgnd_1
X_0892_ _0077_ net79 VGND VGND VPWR VPWR _0040_ sky130_fd_sc_hd__nor2_1
X_1375_ clknet_3_7__leaf_clk _0001_ VGND VGND VPWR VPWR net37 sky130_fd_sc_hd__dfxtp_4
XTAP_TAPCELL_ROW_33_241 VGND VPWR sky130_fd_sc_hd__tapvpwrvgnd_1
Xfanout72 _0197_ VGND VGND VPWR VPWR net72 sky130_fd_sc_hd__buf_6
Xfanout94 net8 VGND VGND VPWR VPWR net94 sky130_fd_sc_hd__buf_6
Xfanout83 net86 VGND VGND VPWR VPWR net83 sky130_fd_sc_hd__buf_2
XFILLER_29_7 VGND VGND VPWR VPWR sky130_fd_sc_hd__fill_1
X_1091_ _0418_ _0417_ net190 net156 VGND VGND VPWR VPWR _0421_ sky130_fd_sc_hd__o211ai_4
X_1160_ _0483_ _0484_ _0480_ VGND VGND VPWR VPWR _0489_ sky130_fd_sc_hd__a21oi_2
Xclkbuf_3_7__f_clk clknet_0_clk VGND VGND VPWR VPWR clknet_3_7__leaf_clk sky130_fd_sc_hd__clkbuf_16
XFILLER_9_250 VGND VGND VPWR VPWR sky130_fd_sc_hd__fill_1
X_0944_ _0275_ _0276_ VGND VGND VPWR VPWR _0277_ sky130_fd_sc_hd__nor2_1
X_0875_ _0195_ _0182_ net57 _0193_ _0222_ VGND VGND VPWR VPWR _0225_ sky130_fd_sc_hd__o2111ai_1
X_1358_ _0679_ net73 VGND VGND VPWR VPWR _0681_ sky130_fd_sc_hd__nor2_1
X_1427_ clknet_3_1__leaf_clk _0053_ VGND VGND VPWR VPWR product_reg\[10\] sky130_fd_sc_hd__dfxtp_1
XFILLER_11_205 VGND VGND VPWR VPWR sky130_fd_sc_hd__decap_6
X_1289_ _0608_ _0609_ _0611_ _0612_ VGND VGND VPWR VPWR _0615_ sky130_fd_sc_hd__and4_1
Xclkload3 clknet_3_3__leaf_clk VGND VGND VPWR VPWR clkload3/Y sky130_fd_sc_hd__bufinv_16
XFILLER_6_253 VGND VGND VPWR VPWR sky130_fd_sc_hd__fill_1
X_1212_ _0451_ _0454_ VGND VGND VPWR VPWR _0540_ sky130_fd_sc_hd__nand2_1
XFILLER_37_146 VPWR VGND VPWR VGND sky130_ef_sc_hd__decap_12
X_1074_ net191 net212 _0402_ VGND VGND VPWR VPWR _0404_ sky130_fd_sc_hd__o21ai_1
X_1143_ _0457_ _0452_ _0470_ _0468_ _0456_ VGND VGND VPWR VPWR _0472_ sky130_fd_sc_hd__o2111a_1
X_0927_ net316 net83 _0085_ _0260_ VGND VGND VPWR VPWR _0046_ sky130_fd_sc_hd__a31o_1
X_0858_ _0212_ _0211_ net82 VGND VGND VPWR VPWR _0024_ sky130_fd_sc_hd__and3_1
X_0789_ net75 net331 net82 _0156_ VGND VGND VPWR VPWR _0011_ sky130_fd_sc_hd__o211a_1
XFILLER_29_26 VGND VGND VPWR VPWR sky130_fd_sc_hd__fill_2
XFILLER_34_127 VGND VGND VPWR VPWR sky130_fd_sc_hd__decap_4
X_0712_ product_reg\[1\] net48 VGND VGND VPWR VPWR _0089_ sky130_fd_sc_hd__nor2_2
X_1126_ net105 net118 _0454_ _0453_ VGND VGND VPWR VPWR _0455_ sky130_fd_sc_hd__a22oi_4
X_1057_ _0386_ VGND VGND VPWR VPWR _0387_ sky130_fd_sc_hd__inv_2
Xoutput49 net49 VGND VGND VPWR VPWR psum[20] sky130_fd_sc_hd__buf_2
Xoutput38 net38 VGND VGND VPWR VPWR psum[10] sky130_fd_sc_hd__buf_2
Xoutput27 net27 VGND VGND VPWR VPWR a_out[6] sky130_fd_sc_hd__buf_2
XFILLER_22_108 VGND VGND VPWR VPWR sky130_fd_sc_hd__decap_3
Xclkbuf_0_clk clk VGND VGND VPWR VPWR clknet_0_clk sky130_fd_sc_hd__clkbuf_16
XFILLER_30_130 VGND VGND VPWR VPWR sky130_fd_sc_hd__decap_4
XFILLER_30_141 VPWR VGND VPWR VGND sky130_ef_sc_hd__decap_12
XPHY_EDGE_ROW_15_Right_15 VGND VGND VPWR VPWR sky130_fd_sc_hd__decap_3
X_1109_ _0438_ VGND VGND VPWR VPWR _0439_ sky130_fd_sc_hd__inv_2
XPHY_EDGE_ROW_24_Right_24 VGND VGND VPWR VPWR sky130_fd_sc_hd__decap_3
XFILLER_26_27 VGND VGND VPWR VPWR sky130_fd_sc_hd__fill_1
XFILLER_42_26 VGND VGND VPWR VPWR sky130_fd_sc_hd__fill_2
XPHY_EDGE_ROW_33_Right_33 VGND VGND VPWR VPWR sky130_fd_sc_hd__decap_3
XFILLER_29_252 VGND VGND VPWR VPWR sky130_fd_sc_hd__fill_2
XPHY_EDGE_ROW_42_Right_42 VGND VGND VPWR VPWR sky130_fd_sc_hd__decap_3
XFILLER_16_93 VGND VGND VPWR VPWR sky130_fd_sc_hd__fill_1
XTAP_TAPCELL_ROW_22_191 VGND VPWR sky130_fd_sc_hd__tapvpwrvgnd_1
X_1391_ clknet_3_7__leaf_clk _0017_ VGND VGND VPWR VPWR net44 sky130_fd_sc_hd__dfxtp_2
XFILLER_12_29 VGND VGND VPWR VPWR sky130_fd_sc_hd__fill_2
Xhold178 net61 VGND VGND VPWR VPWR net314 sky130_fd_sc_hd__dlygate4sd3_1
XFILLER_37_26 VPWR VGND VPWR VGND sky130_ef_sc_hd__decap_12
XTAP_TAPCELL_ROW_5_115 VGND VPWR sky130_fd_sc_hd__tapvpwrvgnd_1
Xhold189 net41 VGND VGND VPWR VPWR net325 sky130_fd_sc_hd__dlygate4sd3_1
XTAP_TAPCELL_ROW_28_217 VGND VPWR sky130_fd_sc_hd__tapvpwrvgnd_1
XFILLER_17_211 VGND VGND VPWR VPWR sky130_fd_sc_hd__decap_3
XTAP_TAPCELL_ROW_42_286 VGND VPWR sky130_fd_sc_hd__tapvpwrvgnd_1
X_0960_ net110 net127 net124 net112 VGND VGND VPWR VPWR _0292_ sky130_fd_sc_hd__a22o_1
X_0891_ _0076_ net79 VGND VGND VPWR VPWR _0039_ sky130_fd_sc_hd__nor2_1
XFILLER_4_181 VGND VGND VPWR VPWR sky130_fd_sc_hd__fill_1
X_1374_ clknet_3_6__leaf_clk _0000_ VGND VGND VPWR VPWR v_pipe sky130_fd_sc_hd__dfxtp_1
XTAP_TAPCELL_ROW_33_242 VGND VPWR sky130_fd_sc_hd__tapvpwrvgnd_1
Xfanout84 net86 VGND VGND VPWR VPWR net84 sky130_fd_sc_hd__clkbuf_2
Xfanout95 net97 VGND VGND VPWR VPWR net95 sky130_fd_sc_hd__buf_6
XTAP_TAPCELL_ROW_0_86 VGND VPWR sky130_fd_sc_hd__tapvpwrvgnd_1
X_1090_ net178 net171 _0413_ _0415_ VGND VGND VPWR VPWR _0420_ sky130_fd_sc_hd__o2bb2ai_4
X_0874_ _0195_ _0182_ _0193_ _0223_ VGND VGND VPWR VPWR _0224_ sky130_fd_sc_hd__o211a_1
X_0943_ net111 net126 net123 net135 VGND VGND VPWR VPWR _0276_ sky130_fd_sc_hd__a22oi_1
X_1288_ _0078_ _0080_ _0527_ _0608_ _0612_ VGND VGND VPWR VPWR _0614_ sky130_fd_sc_hd__o311a_1
X_1357_ net218 net116 _0080_ net87 _0677_ VGND VGND VPWR VPWR _0680_ sky130_fd_sc_hd__a2111oi_1
X_1426_ clknet_3_3__leaf_clk _0052_ VGND VGND VPWR VPWR product_reg\[9\] sky130_fd_sc_hd__dfxtp_1
XFILLER_34_27 VGND VGND VPWR VPWR sky130_fd_sc_hd__fill_1
Xclkload4 clknet_3_4__leaf_clk VGND VGND VPWR VPWR clkload4/Y sky130_fd_sc_hd__bufinv_16
X_1142_ _0457_ _0452_ _0456_ _0470_ VGND VGND VPWR VPWR _0471_ sky130_fd_sc_hd__o211ai_4
X_1211_ _0464_ _0466_ _0534_ _0535_ _0536_ VGND VGND VPWR VPWR _0539_ sky130_fd_sc_hd__o2111ai_4
XFILLER_37_169 VGND VGND VPWR VPWR sky130_fd_sc_hd__fill_1
XFILLER_37_158 VGND VGND VPWR VPWR sky130_fd_sc_hd__decap_4
X_1073_ net184 net134 net96 net93 _0395_ VGND VGND VPWR VPWR _0403_ sky130_fd_sc_hd__a41o_4
X_0857_ _0196_ net52 net75 net74 VGND VGND VPWR VPWR _0212_ sky130_fd_sc_hd__nand4_4
X_0926_ _0259_ net78 net85 _0258_ VGND VGND VPWR VPWR _0260_ sky130_fd_sc_hd__and4b_1
X_1409_ clknet_3_5__leaf_clk _0035_ VGND VGND VPWR VPWR net21 sky130_fd_sc_hd__dfxtp_1
X_0788_ _0154_ _0155_ _0070_ VGND VGND VPWR VPWR _0156_ sky130_fd_sc_hd__a21o_1
XFILLER_34_139 VGND VGND VPWR VPWR sky130_fd_sc_hd__fill_1
X_0711_ net323 _0088_ VGND VGND VPWR VPWR _0001_ sky130_fd_sc_hd__nor2_1
X_1125_ net128 net104 net122 net100 VGND VGND VPWR VPWR _0454_ sky130_fd_sc_hd__nand4_4
X_1056_ _0340_ _0341_ _0343_ _0382_ VGND VGND VPWR VPWR _0386_ sky130_fd_sc_hd__o211ai_4
Xoutput39 net39 VGND VGND VPWR VPWR psum[11] sky130_fd_sc_hd__buf_2
X_0909_ _0242_ _0243_ net85 net78 VGND VGND VPWR VPWR _0244_ sky130_fd_sc_hd__and4b_1
Xoutput28 net28 VGND VGND VPWR VPWR a_out[7] sky130_fd_sc_hd__buf_2
XFILLER_16_139 VGND VGND VPWR VPWR sky130_fd_sc_hd__fill_1
XFILLER_24_150 VGND VGND VPWR VPWR sky130_fd_sc_hd__fill_2
XFILLER_15_194 VPWR VGND VPWR VGND sky130_ef_sc_hd__decap_12
XTAP_TAPCELL_ROW_17_167 VGND VPWR sky130_fd_sc_hd__tapvpwrvgnd_1
XFILLER_30_153 VPWR VGND VPWR VGND sky130_ef_sc_hd__decap_12
XPHY_EDGE_ROW_15_Left_58 VGND VGND VPWR VPWR sky130_fd_sc_hd__decap_3
XFILLER_30_197 VGND VGND VPWR VPWR sky130_fd_sc_hd__decap_8
XFILLER_38_253 VGND VGND VPWR VPWR sky130_fd_sc_hd__fill_1
X_1039_ _0359_ _0361_ _0369_ VGND VGND VPWR VPWR _0370_ sky130_fd_sc_hd__a21o_1
X_1108_ _0358_ _0380_ _0432_ _0431_ VGND VGND VPWR VPWR _0438_ sky130_fd_sc_hd__o211ai_4
XFILLER_12_175 VGND VGND VPWR VPWR sky130_fd_sc_hd__fill_2
XTAP_TAPCELL_ROW_22_192 VGND VPWR sky130_fd_sc_hd__tapvpwrvgnd_1
X_1390_ clknet_3_2__leaf_clk _0016_ VGND VGND VPWR VPWR net43 sky130_fd_sc_hd__dfxtp_1
Xhold179 net63 VGND VGND VPWR VPWR net315 sky130_fd_sc_hd__dlygate4sd3_1
XTAP_TAPCELL_ROW_5_116 VGND VPWR sky130_fd_sc_hd__tapvpwrvgnd_1
XTAP_TAPCELL_ROW_28_218 VGND VPWR sky130_fd_sc_hd__tapvpwrvgnd_1
XTAP_TAPCELL_ROW_42_287 VGND VPWR sky130_fd_sc_hd__tapvpwrvgnd_1
X_0890_ _0073_ net79 VGND VGND VPWR VPWR _0038_ sky130_fd_sc_hd__nor2_1
X_1373_ net87 net80 VGND VGND VPWR VPWR _0066_ sky130_fd_sc_hd__nor2_1
XPHY_EDGE_ROW_18_Left_61 VGND VGND VPWR VPWR sky130_fd_sc_hd__decap_3
Xfanout74 _0210_ VGND VGND VPWR VPWR net74 sky130_fd_sc_hd__clkbuf_2
Xfanout96 net97 VGND VGND VPWR VPWR net96 sky130_fd_sc_hd__buf_8
Xfanout85 net86 VGND VGND VPWR VPWR net85 sky130_fd_sc_hd__clkbuf_2
XTAP_TAPCELL_ROW_0_87 VGND VPWR sky130_fd_sc_hd__tapvpwrvgnd_1
X_0873_ net74 _0216_ _0221_ VGND VGND VPWR VPWR _0223_ sky130_fd_sc_hd__and3_1
X_0942_ net111 net135 net126 net123 VGND VGND VPWR VPWR _0275_ sky130_fd_sc_hd__and4_1
X_1425_ clknet_3_6__leaf_clk _0051_ VGND VGND VPWR VPWR product_reg\[8\] sky130_fd_sc_hd__dfxtp_1
X_1287_ _0608_ _0609_ _0611_ _0612_ VGND VGND VPWR VPWR _0613_ sky130_fd_sc_hd__a22oi_4
X_1356_ _0080_ net87 _0632_ _0677_ VGND VGND VPWR VPWR _0679_ sky130_fd_sc_hd__o31a_1
XFILLER_11_218 VGND VGND VPWR VPWR sky130_fd_sc_hd__decap_6
XFILLER_11_229 VGND VGND VPWR VPWR sky130_fd_sc_hd__decap_3
Xclkload5 clknet_3_5__leaf_clk VGND VGND VPWR VPWR clkload5/X sky130_fd_sc_hd__clkbuf_4
XPHY_EDGE_ROW_3_Left_46 VGND VGND VPWR VPWR sky130_fd_sc_hd__decap_3
XFILLER_24_72 VGND VGND VPWR VPWR sky130_fd_sc_hd__fill_1
XFILLER_24_83 VGND VGND VPWR VPWR sky130_fd_sc_hd__fill_1
XFILLER_40_82 VGND VGND VPWR VPWR sky130_fd_sc_hd__fill_2
X_1141_ _0329_ _0461_ _0460_ _0397_ _0465_ VGND VGND VPWR VPWR _0470_ sky130_fd_sc_hd__o2111ai_4
X_1072_ _0074_ _0077_ _0396_ _0398_ VGND VGND VPWR VPWR _0402_ sky130_fd_sc_hd__o22ai_4
X_1210_ _0464_ _0466_ _0536_ _0535_ _0534_ VGND VGND VPWR VPWR _0538_ sky130_fd_sc_hd__o2111a_1
X_0856_ net75 _0196_ net74 net52 VGND VGND VPWR VPWR _0211_ sky130_fd_sc_hd__a31o_1
X_0925_ _0256_ _0257_ _0242_ VGND VGND VPWR VPWR _0259_ sky130_fd_sc_hd__a21oi_1
X_0787_ product_reg\[9\] net68 _0151_ _0152_ _0153_ VGND VGND VPWR VPWR _0155_ sky130_fd_sc_hd__o2111ai_4
X_1408_ clknet_3_0__leaf_clk _0034_ VGND VGND VPWR VPWR net70 sky130_fd_sc_hd__dfxtp_1
X_1339_ _0610_ _0661_ _0662_ VGND VGND VPWR VPWR _0663_ sky130_fd_sc_hd__o21ai_1
XFILLER_19_83 VGND VGND VPWR VPWR sky130_fd_sc_hd__fill_2
X_0710_ product_reg\[0\] net76 net37 net80 VGND VGND VPWR VPWR _0088_ sky130_fd_sc_hd__a31o_1
X_1124_ net102 net121 net100 net125 VGND VGND VPWR VPWR _0453_ sky130_fd_sc_hd__a22o_4
X_1055_ _0383_ net117 net113 _0342_ VGND VGND VPWR VPWR _0385_ sky130_fd_sc_hd__nand4_2
X_0839_ _0196_ net45 net44 net77 VGND VGND VPWR VPWR _0200_ sky130_fd_sc_hd__nand4_1
X_0908_ _0240_ _0241_ _0234_ VGND VGND VPWR VPWR _0243_ sky130_fd_sc_hd__o21ai_1
Xoutput29 net29 VGND VGND VPWR VPWR b_out[0] sky130_fd_sc_hd__buf_2
XTAP_TAPCELL_ROW_17_168 VGND VPWR sky130_fd_sc_hd__tapvpwrvgnd_1
XFILLER_30_110 VPWR VGND VPWR VGND sky130_ef_sc_hd__decap_12
XFILLER_30_165 VPWR VGND VPWR VGND sky130_ef_sc_hd__decap_12
XPHY_EDGE_ROW_5_Right_5 VGND VGND VPWR VPWR sky130_fd_sc_hd__decap_3
X_1038_ _0366_ _0367_ VGND VGND VPWR VPWR _0369_ sky130_fd_sc_hd__nand2_2
X_1107_ _0381_ _0434_ _0433_ VGND VGND VPWR VPWR _0437_ sky130_fd_sc_hd__nand3_4
XFILLER_21_110 VGND VGND VPWR VPWR sky130_fd_sc_hd__fill_2
XFILLER_26_29 VPWR VGND VPWR VGND sky130_ef_sc_hd__decap_12
XFILLER_29_232 VGND VGND VPWR VPWR sky130_fd_sc_hd__decap_3
XFILLER_12_154 VGND VGND VPWR VPWR sky130_fd_sc_hd__decap_4
XFILLER_16_62 VPWR VGND VPWR VGND sky130_ef_sc_hd__decap_12
XPHY_EDGE_ROW_32_Left_75 VGND VGND VPWR VPWR sky130_fd_sc_hd__decap_3
XTAP_TAPCELL_ROW_22_193 VGND VPWR sky130_fd_sc_hd__tapvpwrvgnd_1
XFILLER_32_83 VGND VGND VPWR VPWR sky130_fd_sc_hd__fill_1
XFILLER_26_224 VGND VGND VPWR VPWR sky130_fd_sc_hd__fill_1
XTAP_TAPCELL_ROW_28_219 VGND VPWR sky130_fd_sc_hd__tapvpwrvgnd_1
XTAP_TAPCELL_ROW_36_252 VGND VPWR sky130_fd_sc_hd__tapvpwrvgnd_1
X_1372_ _0079_ net79 VGND VGND VPWR VPWR _0065_ sky130_fd_sc_hd__nor2_1
XFILLER_23_19 VGND VGND VPWR VPWR sky130_fd_sc_hd__fill_1
XTAP_TAPCELL_ROW_24_200 VGND VPWR sky130_fd_sc_hd__tapvpwrvgnd_1
Xfanout86 _0082_ VGND VGND VPWR VPWR net86 sky130_fd_sc_hd__clkbuf_2
Xfanout75 v_pipe VGND VGND VPWR VPWR net75 sky130_fd_sc_hd__buf_2
XFILLER_13_63 VGND VGND VPWR VPWR sky130_fd_sc_hd__decap_3
Xfanout97 net98 VGND VGND VPWR VPWR net97 sky130_fd_sc_hd__buf_8
XFILLER_38_71 VGND VGND VPWR VPWR sky130_fd_sc_hd__decap_4
XTAP_TAPCELL_ROW_0_88 VGND VPWR sky130_fd_sc_hd__tapvpwrvgnd_1
X_0941_ net111 net123 VGND VGND VPWR VPWR _0274_ sky130_fd_sc_hd__nand2_1
X_0872_ net74 _0216_ _0221_ VGND VGND VPWR VPWR _0222_ sky130_fd_sc_hd__and3_1
XFILLER_9_242 VGND VGND VPWR VPWR sky130_fd_sc_hd__decap_8
XTAP_TAPCELL_ROW_30_225 VGND VPWR sky130_fd_sc_hd__tapvpwrvgnd_1
X_1355_ _0080_ net87 _0632_ _0677_ VGND VGND VPWR VPWR _0678_ sky130_fd_sc_hd__or4b_1
X_1424_ clknet_3_6__leaf_clk _0050_ VGND VGND VPWR VPWR product_reg\[7\] sky130_fd_sc_hd__dfxtp_1
X_1286_ net216 net120 net94 net122 VGND VGND VPWR VPWR _0612_ sky130_fd_sc_hd__a22o_1
Xclkload6 clknet_3_7__leaf_clk VGND VGND VPWR VPWR clkload6/X sky130_fd_sc_hd__clkbuf_4
XFILLER_34_29 VGND VGND VPWR VPWR sky130_fd_sc_hd__fill_1
X_1140_ _0329_ _0461_ _0465_ _0397_ _0460_ VGND VGND VPWR VPWR _0469_ sky130_fd_sc_hd__o2111a_1
X_1071_ _0396_ net201 _0395_ VGND VGND VPWR VPWR _0401_ sky130_fd_sc_hd__o21bai_4
X_0924_ _0256_ _0257_ _0242_ VGND VGND VPWR VPWR _0258_ sky130_fd_sc_hd__nand3_1
X_0855_ net297 net74 _0209_ net80 VGND VGND VPWR VPWR _0023_ sky130_fd_sc_hd__a211oi_2
X_0786_ _0151_ _0152_ _0153_ _0146_ VGND VGND VPWR VPWR _0154_ sky130_fd_sc_hd__a22o_1
X_1338_ _0639_ _0660_ VGND VGND VPWR VPWR _0662_ sky130_fd_sc_hd__nand2_1
X_1407_ clknet_3_0__leaf_clk _0033_ VGND VGND VPWR VPWR net69 sky130_fd_sc_hd__dfxtp_1
XFILLER_28_138 VGND VGND VPWR VPWR sky130_fd_sc_hd__fill_2
XFILLER_29_18 VGND VGND VPWR VPWR sky130_fd_sc_hd__decap_8
X_1269_ _0595_ _0594_ _0592_ VGND VGND VPWR VPWR _0596_ sky130_fd_sc_hd__nand3b_1
X_1123_ net102 net122 net100 net128 VGND VGND VPWR VPWR _0452_ sky130_fd_sc_hd__a22oi_4
X_1054_ _0383_ net113 _0342_ net117 VGND VGND VPWR VPWR _0384_ sky130_fd_sc_hd__and4_2
X_0907_ _0234_ _0240_ _0241_ VGND VGND VPWR VPWR _0242_ sky130_fd_sc_hd__nor3_2
X_0838_ net77 net44 _0196_ net45 VGND VGND VPWR VPWR _0199_ sky130_fd_sc_hd__a31o_1
X_0769_ product_reg\[8\] net67 VGND VGND VPWR VPWR _0139_ sky130_fd_sc_hd__or2_1
XFILLER_21_63 VPWR VGND VPWR VGND sky130_ef_sc_hd__decap_12
XTAP_TAPCELL_ROW_17_169 VGND VPWR sky130_fd_sc_hd__tapvpwrvgnd_1
XFILLER_30_122 VGND VGND VPWR VPWR sky130_fd_sc_hd__fill_2
XFILLER_30_177 VPWR VGND VPWR VGND sky130_ef_sc_hd__decap_12
Xclone161 net72 VGND VGND VPWR VPWR net297 sky130_fd_sc_hd__buf_6
X_1106_ _0434_ _0381_ _0433_ VGND VGND VPWR VPWR _0436_ sky130_fd_sc_hd__and3_1
XFILLER_42_29 VGND VGND VPWR VPWR sky130_fd_sc_hd__decap_4
X_1037_ _0362_ _0365_ VGND VGND VPWR VPWR _0368_ sky130_fd_sc_hd__xor2_1
XTAP_TAPCELL_ROW_8_126 VGND VPWR sky130_fd_sc_hd__tapvpwrvgnd_1
XFILLER_8_126 VGND VGND VPWR VPWR sky130_fd_sc_hd__fill_1
XPHY_EDGE_ROW_11_Right_11 VGND VGND VPWR VPWR sky130_fd_sc_hd__decap_3
XFILLER_16_85 VGND VGND VPWR VPWR sky130_fd_sc_hd__decap_8
XPHY_EDGE_ROW_20_Right_20 VGND VGND VPWR VPWR sky130_fd_sc_hd__decap_3
XFILLER_7_192 VGND VGND VPWR VPWR sky130_fd_sc_hd__fill_1
XTAP_TAPCELL_ROW_13_150 VGND VPWR sky130_fd_sc_hd__tapvpwrvgnd_1
XTAP_TAPCELL_ROW_36_253 VGND VPWR sky130_fd_sc_hd__tapvpwrvgnd_1
XFILLER_17_203 VGND VGND VPWR VPWR sky130_fd_sc_hd__decap_8
XFILLER_17_225 VGND VGND VPWR VPWR sky130_fd_sc_hd__decap_4
XFILLER_4_195 VGND VGND VPWR VPWR sky130_fd_sc_hd__fill_1
X_1371_ _0078_ net80 VGND VGND VPWR VPWR _0064_ sky130_fd_sc_hd__nor2_1
X_1440_ clknet_3_4__leaf_clk _0066_ VGND VGND VPWR VPWR net36 sky130_fd_sc_hd__dfxtp_1
Xclkbuf_3_2__f_clk clknet_0_clk VGND VGND VPWR VPWR clknet_3_2__leaf_clk sky130_fd_sc_hd__clkbuf_16
XTAP_TAPCELL_ROW_24_201 VGND VPWR sky130_fd_sc_hd__tapvpwrvgnd_1
Xfanout87 _0081_ VGND VGND VPWR VPWR net87 sky130_fd_sc_hd__buf_4
Xfanout98 net7 VGND VGND VPWR VPWR net98 sky130_fd_sc_hd__buf_6
Xfanout76 net77 VGND VGND VPWR VPWR net76 sky130_fd_sc_hd__buf_2
XTAP_TAPCELL_ROW_0_89 VGND VPWR sky130_fd_sc_hd__tapvpwrvgnd_1
XFILLER_38_83 VGND VGND VPWR VPWR sky130_fd_sc_hd__fill_1
X_0940_ _0265_ _0271_ _0262_ _0270_ VGND VGND VPWR VPWR _0273_ sky130_fd_sc_hd__o211ai_4
XFILLER_20_209 VGND VGND VPWR VPWR sky130_fd_sc_hd__fill_2
XTAP_TAPCELL_ROW_30_226 VGND VPWR sky130_fd_sc_hd__tapvpwrvgnd_1
X_0871_ net75 net56 net55 VGND VGND VPWR VPWR _0221_ sky130_fd_sc_hd__and3_1
X_1285_ net121 net97 net118 net94 VGND VGND VPWR VPWR _0611_ sky130_fd_sc_hd__nand4_4
X_1354_ _0610_ _0661_ _0662_ _0658_ VGND VGND VPWR VPWR _0677_ sky130_fd_sc_hd__a2bb2o_1
X_1423_ clknet_3_6__leaf_clk _0049_ VGND VGND VPWR VPWR product_reg\[6\] sky130_fd_sc_hd__dfxtp_1
XFILLER_10_253 VGND VGND VPWR VPWR sky130_fd_sc_hd__fill_1
X_1070_ _0074_ _0077_ _0397_ _0399_ VGND VGND VPWR VPWR _0400_ sky130_fd_sc_hd__o211ai_2
X_0854_ net51 net50 net49 _0204_ VGND VGND VPWR VPWR _0210_ sky130_fd_sc_hd__and4_1
X_0923_ net135 net126 _0254_ _0255_ VGND VGND VPWR VPWR _0257_ sky130_fd_sc_hd__a22o_1
X_0785_ _0138_ _0145_ _0144_ VGND VGND VPWR VPWR _0153_ sky130_fd_sc_hd__nand3_4
X_1406_ clknet_3_2__leaf_clk _0032_ VGND VGND VPWR VPWR net61 sky130_fd_sc_hd__dfxtp_1
X_1268_ net110 net115 _0543_ _0541_ VGND VGND VPWR VPWR _0595_ sky130_fd_sc_hd__a31oi_1
X_1337_ _0636_ _0637_ _0660_ VGND VGND VPWR VPWR _0661_ sky130_fd_sc_hd__a21o_1
XFILLER_28_106 VGND VGND VPWR VPWR sky130_fd_sc_hd__fill_2
XFILLER_36_194 VGND VGND VPWR VPWR sky130_fd_sc_hd__fill_2
XFILLER_36_161 VGND VGND VPWR VPWR sky130_fd_sc_hd__fill_1
X_1199_ net121 net216 VGND VGND VPWR VPWR _0527_ sky130_fd_sc_hd__nand2_1
XFILLER_42_186 VGND VGND VPWR VPWR sky130_fd_sc_hd__decap_3
X_1122_ net105 net118 VGND VGND VPWR VPWR _0451_ sky130_fd_sc_hd__nand2_1
X_1053_ _0340_ _0343_ VGND VGND VPWR VPWR _0383_ sky130_fd_sc_hd__nand2_1
X_0837_ net326 net297 _0198_ VGND VGND VPWR VPWR _0017_ sky130_fd_sc_hd__a21oi_1
X_0906_ _0237_ _0239_ net129 net135 VGND VGND VPWR VPWR _0241_ sky130_fd_sc_hd__and4b_1
X_0699_ net116 VGND VGND VPWR VPWR _0079_ sky130_fd_sc_hd__inv_4
X_0768_ product_reg\[8\] net67 VGND VGND VPWR VPWR _0138_ sky130_fd_sc_hd__nand2_1
XFILLER_24_197 VGND VGND VPWR VPWR sky130_fd_sc_hd__decap_3
XFILLER_21_75 VGND VGND VPWR VPWR sky130_fd_sc_hd__fill_1
XFILLER_21_86 VGND VGND VPWR VPWR sky130_fd_sc_hd__decap_8
Xmax_cap73 _0680_ VGND VGND VPWR VPWR net73 sky130_fd_sc_hd__clkbuf_1
XFILLER_30_134 VGND VGND VPWR VPWR sky130_fd_sc_hd__fill_1
XFILLER_30_189 VGND VGND VPWR VPWR sky130_fd_sc_hd__decap_6
XFILLER_30_3 VPWR VGND VPWR VGND sky130_ef_sc_hd__decap_12
Xclone162 _0197_ VGND VGND VPWR VPWR net298 sky130_fd_sc_hd__buf_6
X_1105_ _0431_ _0432_ VGND VGND VPWR VPWR _0435_ sky130_fd_sc_hd__nand2_1
X_1036_ _0291_ _0363_ net136 net117 VGND VGND VPWR VPWR _0367_ sky130_fd_sc_hd__a2bb2o_1
XTAP_TAPCELL_ROW_8_127 VGND VPWR sky130_fd_sc_hd__tapvpwrvgnd_1
XTAP_TAPCELL_ROW_13_151 VGND VPWR sky130_fd_sc_hd__tapvpwrvgnd_1
XTAP_TAPCELL_ROW_36_254 VGND VPWR sky130_fd_sc_hd__tapvpwrvgnd_1
X_1019_ _0346_ _0342_ _0344_ VGND VGND VPWR VPWR _0350_ sky130_fd_sc_hd__a21oi_2
XTAP_TAPCELL_ROW_42_279 VGND VPWR sky130_fd_sc_hd__tapvpwrvgnd_1
X_1370_ net124 net85 VGND VGND VPWR VPWR _0063_ sky130_fd_sc_hd__and2_1
XFILLER_14_207 VGND VGND VPWR VPWR sky130_fd_sc_hd__decap_6
XTAP_TAPCELL_ROW_24_202 VGND VPWR sky130_fd_sc_hd__tapvpwrvgnd_1
Xfanout88 net90 VGND VGND VPWR VPWR net88 sky130_fd_sc_hd__buf_12
Xfanout99 net101 VGND VGND VPWR VPWR net99 sky130_fd_sc_hd__buf_6
Xfanout77 v_pipe VGND VGND VPWR VPWR net77 sky130_fd_sc_hd__buf_2
XFILLER_8_3 VGND VGND VPWR VPWR sky130_fd_sc_hd__fill_1
X_0870_ net308 net338 _0218_ net79 _0220_ VGND VGND VPWR VPWR _0028_ sky130_fd_sc_hd__a311oi_1
XTAP_TAPCELL_ROW_30_227 VGND VPWR sky130_fd_sc_hd__tapvpwrvgnd_1
X_1422_ clknet_3_4__leaf_clk _0048_ VGND VGND VPWR VPWR product_reg\[5\] sky130_fd_sc_hd__dfxtp_1
X_1284_ net118 net94 VGND VGND VPWR VPWR _0610_ sky130_fd_sc_hd__nand2_1
X_1353_ _0653_ _0654_ _0672_ _0675_ VGND VGND VPWR VPWR _0676_ sky130_fd_sc_hd__a31oi_1
X_0999_ net199 net131 net187 net147 VGND VGND VPWR VPWR _0330_ sky130_fd_sc_hd__and4_1
XFILLER_24_97 VGND VGND VPWR VPWR sky130_fd_sc_hd__decap_3
XFILLER_37_129 VGND VGND VPWR VPWR sky130_fd_sc_hd__fill_1
X_0853_ net71 net49 net50 _0204_ net310 VGND VGND VPWR VPWR _0209_ sky130_fd_sc_hd__a41oi_2
X_0922_ _0250_ _0251_ _0252_ _0253_ _0245_ VGND VGND VPWR VPWR _0256_ sky130_fd_sc_hd__a311o_1
X_1405_ clknet_3_2__leaf_clk _0031_ VGND VGND VPWR VPWR net60 sky130_fd_sc_hd__dfxtp_1
X_0784_ product_reg\[10\] net38 VGND VGND VPWR VPWR _0152_ sky130_fd_sc_hd__or2_1
Xinput1 a_in[0] VGND VGND VPWR VPWR net1 sky130_fd_sc_hd__clkbuf_1
X_1198_ net125 net95 net99 net121 VGND VGND VPWR VPWR _0526_ sky130_fd_sc_hd__a22o_1
X_1336_ net94 net114 _0632_ _0659_ VGND VGND VPWR VPWR _0660_ sky130_fd_sc_hd__a31o_1
X_1267_ _0590_ _0589_ _0588_ VGND VGND VPWR VPWR _0594_ sky130_fd_sc_hd__nand3_1
XFILLER_3_228 VGND VGND VPWR VPWR sky130_fd_sc_hd__fill_2
XFILLER_19_118 VGND VGND VPWR VPWR sky130_fd_sc_hd__fill_1
XFILLER_19_75 VGND VGND VPWR VPWR sky130_fd_sc_hd__decap_8
XFILLER_27_173 VGND VGND VPWR VPWR sky130_fd_sc_hd__decap_4
XFILLER_35_41 VGND VGND VPWR VPWR sky130_fd_sc_hd__fill_1
XFILLER_32_7 VGND VGND VPWR VPWR sky130_fd_sc_hd__decap_4
X_1052_ net113 net117 VGND VGND VPWR VPWR _0382_ sky130_fd_sc_hd__nand2_1
X_1121_ product_reg\[7\] _0232_ _0450_ _0449_ VGND VGND VPWR VPWR _0050_ sky130_fd_sc_hd__a22o_1
X_0836_ net44 net297 net84 VGND VGND VPWR VPWR _0198_ sky130_fd_sc_hd__o21ai_2
X_0905_ _0074_ _0075_ _0237_ _0238_ VGND VGND VPWR VPWR _0240_ sky130_fd_sc_hd__o22a_1
X_0767_ _0135_ _0136_ net77 _0137_ VGND VGND VPWR VPWR _0008_ sky130_fd_sc_hd__a31oi_1
X_0698_ net119 VGND VGND VPWR VPWR _0078_ sky130_fd_sc_hd__clkinv_4
X_1319_ _0631_ _0641_ _0642_ VGND VGND VPWR VPWR _0644_ sky130_fd_sc_hd__and3_1
XFILLER_21_54 VGND VGND VPWR VPWR sky130_fd_sc_hd__fill_2
XFILLER_21_98 VGND VGND VPWR VPWR sky130_fd_sc_hd__decap_3
X_1104_ _0388_ _0389_ _0427_ _0429_ VGND VGND VPWR VPWR _0434_ sky130_fd_sc_hd__o22ai_2
X_1035_ _0075_ _0079_ _0291_ _0363_ VGND VGND VPWR VPWR _0366_ sky130_fd_sc_hd__or4_4
XTAP_TAPCELL_ROW_8_128 VGND VPWR sky130_fd_sc_hd__tapvpwrvgnd_1
X_0819_ _0173_ net40 product_reg\[12\] _0174_ VGND VGND VPWR VPWR _0183_ sky130_fd_sc_hd__a31o_1
XFILLER_8_139 VGND VGND VPWR VPWR sky130_fd_sc_hd__fill_1
XFILLER_32_75 VGND VGND VPWR VPWR sky130_fd_sc_hd__decap_8
XTAP_TAPCELL_ROW_13_152 VGND VPWR sky130_fd_sc_hd__tapvpwrvgnd_1
XPHY_EDGE_ROW_9_Right_9 VGND VGND VPWR VPWR sky130_fd_sc_hd__decap_3
XTAP_TAPCELL_ROW_36_255 VGND VPWR sky130_fd_sc_hd__tapvpwrvgnd_1
X_1018_ _0341_ _0347_ _0345_ VGND VGND VPWR VPWR _0349_ sky130_fd_sc_hd__o21ai_1
XPHY_EDGE_ROW_36_Left_79 VGND VGND VPWR VPWR sky130_fd_sc_hd__decap_3
XFILLER_27_53 VGND VGND VPWR VPWR sky130_fd_sc_hd__decap_3
XFILLER_27_75 VGND VGND VPWR VPWR sky130_fd_sc_hd__fill_2
XFILLER_31_252 VGND VGND VPWR VPWR sky130_fd_sc_hd__fill_2
Xfanout89 net90 VGND VGND VPWR VPWR net89 sky130_fd_sc_hd__clkbuf_2
XFILLER_22_241 VGND VGND VPWR VPWR sky130_fd_sc_hd__decap_6
Xfanout78 _0084_ VGND VGND VPWR VPWR net78 sky130_fd_sc_hd__buf_2
XFILLER_38_41 VGND VGND VPWR VPWR sky130_fd_sc_hd__fill_2
XFILLER_1_178 VGND VGND VPWR VPWR sky130_fd_sc_hd__fill_2
XFILLER_38_85 VGND VGND VPWR VPWR sky130_fd_sc_hd__decap_4
XTAP_TAPCELL_ROW_30_228 VGND VPWR sky130_fd_sc_hd__tapvpwrvgnd_1
X_1421_ clknet_3_4__leaf_clk _0047_ VGND VGND VPWR VPWR product_reg\[4\] sky130_fd_sc_hd__dfxtp_1
X_1283_ _0606_ _0607_ net102 net114 VGND VGND VPWR VPWR _0609_ sky130_fd_sc_hd__nand4_4
X_1352_ _0674_ VGND VGND VPWR VPWR _0675_ sky130_fd_sc_hd__inv_2
X_0998_ net134 net95 VGND VGND VPWR VPWR _0329_ sky130_fd_sc_hd__nand2_2
XPHY_EDGE_ROW_39_Left_82 VGND VGND VPWR VPWR sky130_fd_sc_hd__decap_3
X_0921_ _0250_ _0251_ _0252_ VGND VGND VPWR VPWR _0255_ sky130_fd_sc_hd__nand3_1
XPHY_EDGE_ROW_23_Left_66 VGND VGND VPWR VPWR sky130_fd_sc_hd__decap_3
X_0852_ _0205_ _0208_ net83 _0207_ VGND VGND VPWR VPWR _0022_ sky130_fd_sc_hd__o211a_1
X_0783_ product_reg\[10\] net38 VGND VGND VPWR VPWR _0151_ sky130_fd_sc_hd__nand2_2
X_1404_ clknet_3_2__leaf_clk _0030_ VGND VGND VPWR VPWR net58 sky130_fd_sc_hd__dfxtp_1
X_1335_ net116 net94 net114 net215 VGND VGND VPWR VPWR _0659_ sky130_fd_sc_hd__a22oi_1
XFILLER_36_141 VPWR VGND VPWR VGND sky130_ef_sc_hd__decap_12
Xinput2 a_in[1] VGND VGND VPWR VPWR net2 sky130_fd_sc_hd__clkbuf_1
X_1197_ net125 net95 net99 net121 VGND VGND VPWR VPWR _0525_ sky130_fd_sc_hd__a22oi_4
X_1266_ _0590_ _0589_ _0588_ VGND VGND VPWR VPWR _0593_ sky130_fd_sc_hd__and3_1
XFILLER_19_65 VGND VGND VPWR VPWR sky130_fd_sc_hd__decap_6
XFILLER_42_166 VGND VGND VPWR VPWR sky130_fd_sc_hd__fill_2
X_1051_ _0356_ _0352_ _0351_ _0361_ _0369_ VGND VGND VPWR VPWR _0381_ sky130_fd_sc_hd__a32oi_4
XFILLER_18_152 VGND VGND VPWR VPWR sky130_fd_sc_hd__fill_1
X_1120_ _0379_ _0448_ _0086_ VGND VGND VPWR VPWR _0450_ sky130_fd_sc_hd__a21oi_1
X_0904_ net219 net109 net112 net133 VGND VGND VPWR VPWR _0239_ sky130_fd_sc_hd__a22o_1
X_0835_ _0182_ _0195_ net75 _0193_ VGND VGND VPWR VPWR _0197_ sky130_fd_sc_hd__o211a_1
X_0697_ net99 VGND VGND VPWR VPWR _0077_ sky130_fd_sc_hd__clkinv_4
X_0766_ _0070_ _0071_ net17 net18 VGND VGND VPWR VPWR _0137_ sky130_fd_sc_hd__a211o_1
X_1318_ _0641_ _0642_ _0631_ VGND VGND VPWR VPWR _0643_ sky130_fd_sc_hd__a21oi_1
X_1249_ net99 net118 VGND VGND VPWR VPWR _0576_ sky130_fd_sc_hd__nand2_2
XFILLER_24_122 VGND VGND VPWR VPWR sky130_fd_sc_hd__fill_1
XFILLER_7_57 VGND VGND VPWR VPWR sky130_fd_sc_hd__fill_1
X_1103_ _0390_ _0391_ _0428_ net159 VGND VGND VPWR VPWR _0433_ sky130_fd_sc_hd__o211ai_2
X_1034_ _0075_ _0078_ _0291_ _0290_ VGND VGND VPWR VPWR _0365_ sky130_fd_sc_hd__o31a_1
XTAP_TAPCELL_ROW_8_129 VGND VPWR sky130_fd_sc_hd__tapvpwrvgnd_1
XPHY_EDGE_ROW_10_Left_53 VGND VGND VPWR VPWR sky130_fd_sc_hd__decap_3
X_0818_ _0167_ _0169_ _0181_ VGND VGND VPWR VPWR _0182_ sky130_fd_sc_hd__a21boi_4
X_0749_ _0117_ _0120_ _0121_ VGND VGND VPWR VPWR _0122_ sky130_fd_sc_hd__a21oi_1
XFILLER_12_158 VGND VGND VPWR VPWR sky130_fd_sc_hd__fill_1
XTAP_TAPCELL_ROW_36_256 VGND VPWR sky130_fd_sc_hd__tapvpwrvgnd_1
X_1017_ _0342_ _0343_ net113 net119 VGND VGND VPWR VPWR _0348_ sky130_fd_sc_hd__and4_1
XTAP_TAPCELL_ROW_4_110 VGND VPWR sky130_fd_sc_hd__tapvpwrvgnd_1
XTAP_TAPCELL_ROW_27_212 VGND VPWR sky130_fd_sc_hd__tapvpwrvgnd_1
XFILLER_40_253 VGND VGND VPWR VPWR sky130_fd_sc_hd__fill_1
Xclone63 net90 VGND VGND VPWR VPWR net199 sky130_fd_sc_hd__clkbuf_1
XFILLER_13_23 VGND VGND VPWR VPWR sky130_fd_sc_hd__fill_1
Xfanout79 _0083_ VGND VGND VPWR VPWR net79 sky130_fd_sc_hd__buf_4
XFILLER_22_253 VGND VGND VPWR VPWR sky130_fd_sc_hd__fill_1
XFILLER_13_253 VGND VGND VPWR VPWR sky130_fd_sc_hd__fill_1
XTAP_TAPCELL_ROW_30_229 VGND VPWR sky130_fd_sc_hd__tapvpwrvgnd_1
X_1351_ _0648_ _0666_ _0665_ VGND VGND VPWR VPWR _0674_ sky130_fd_sc_hd__a21oi_2
X_1420_ clknet_3_4__leaf_clk _0046_ VGND VGND VPWR VPWR product_reg\[3\] sky130_fd_sc_hd__dfxtp_1
X_1282_ _0606_ _0607_ _0076_ net87 VGND VGND VPWR VPWR _0608_ sky130_fd_sc_hd__o2bb2ai_2
X_0997_ net197 net186 net147 net131 VGND VGND VPWR VPWR _0328_ sky130_fd_sc_hd__a22o_4
XFILLER_24_44 VGND VGND VPWR VPWR sky130_fd_sc_hd__fill_2
XFILLER_24_66 VGND VGND VPWR VPWR sky130_fd_sc_hd__fill_1
X_0920_ _0250_ _0251_ _0252_ VGND VGND VPWR VPWR _0254_ sky130_fd_sc_hd__a21o_1
X_0851_ net336 net49 VGND VGND VPWR VPWR _0208_ sky130_fd_sc_hd__nand2_1
X_0782_ _0148_ _0149_ _0150_ net83 VGND VGND VPWR VPWR _0010_ sky130_fd_sc_hd__o211a_1
X_1403_ clknet_3_2__leaf_clk _0029_ VGND VGND VPWR VPWR net57 sky130_fd_sc_hd__dfxtp_1
X_1334_ _0077_ net87 _0635_ _0611_ _0079_ VGND VGND VPWR VPWR _0658_ sky130_fd_sc_hd__o32ai_2
XPHY_EDGE_ROW_18_Right_18 VGND VGND VPWR VPWR sky130_fd_sc_hd__decap_3
X_1265_ _0588_ _0589_ _0590_ VGND VGND VPWR VPWR _0592_ sky130_fd_sc_hd__a21o_1
XFILLER_36_153 VGND VGND VPWR VPWR sky130_fd_sc_hd__decap_4
Xinput3 a_in[2] VGND VGND VPWR VPWR net3 sky130_fd_sc_hd__clkbuf_1
X_1196_ net102 net118 VGND VGND VPWR VPWR _0524_ sky130_fd_sc_hd__nand2_1
XPHY_EDGE_ROW_27_Right_27 VGND VGND VPWR VPWR sky130_fd_sc_hd__decap_3
XPHY_EDGE_ROW_36_Right_36 VGND VGND VPWR VPWR sky130_fd_sc_hd__decap_3
XPHY_EDGE_ROW_40_Left_83 VGND VGND VPWR VPWR sky130_fd_sc_hd__decap_3
XFILLER_42_178 VGND VGND VPWR VPWR sky130_fd_sc_hd__fill_1
XFILLER_42_156 VGND VGND VPWR VPWR sky130_fd_sc_hd__fill_1
X_1050_ _0353_ _0355_ _0357_ _0368_ VGND VGND VPWR VPWR _0380_ sky130_fd_sc_hd__a31oi_2
X_0834_ net302 _0195_ _0193_ VGND VGND VPWR VPWR _0196_ sky130_fd_sc_hd__o21a_4
X_0903_ net219 net109 net112 net133 VGND VGND VPWR VPWR _0238_ sky130_fd_sc_hd__a22oi_1
X_0765_ _0131_ _0133_ _0134_ VGND VGND VPWR VPWR _0136_ sky130_fd_sc_hd__o21ai_1
X_0696_ net102 VGND VGND VPWR VPWR _0076_ sky130_fd_sc_hd__clkinv_4
X_1248_ _0573_ net114 net105 _0572_ VGND VGND VPWR VPWR _0575_ sky130_fd_sc_hd__nand4_2
X_1317_ _0638_ _0639_ _0614_ _0609_ VGND VGND VPWR VPWR _0642_ sky130_fd_sc_hd__a22o_1
X_1179_ _0075_ _0079_ _0291_ _0363_ _0437_ VGND VGND VPWR VPWR _0508_ sky130_fd_sc_hd__o41ai_4
XFILLER_15_167 VGND VGND VPWR VPWR sky130_fd_sc_hd__fill_1
XFILLER_30_104 VGND VGND VPWR VPWR sky130_fd_sc_hd__decap_3
X_1102_ _0390_ _0391_ _0429_ net207 VGND VGND VPWR VPWR _0432_ sky130_fd_sc_hd__o22ai_4
XTAP_TAPCELL_ROW_16_162 VGND VPWR sky130_fd_sc_hd__tapvpwrvgnd_1
X_1033_ _0292_ net120 net136 _0289_ VGND VGND VPWR VPWR _0364_ sky130_fd_sc_hd__a31o_1
X_0817_ _0165_ _0173_ _0175_ VGND VGND VPWR VPWR _0181_ sky130_fd_sc_hd__and3_1
X_0748_ _0117_ _0120_ net76 VGND VGND VPWR VPWR _0121_ sky130_fd_sc_hd__o21ai_1
XPHY_EDGE_ROW_0_Right_0 VGND VGND VPWR VPWR sky130_fd_sc_hd__decap_3
XFILLER_16_78 VGND VGND VPWR VPWR sky130_fd_sc_hd__decap_6
XFILLER_32_44 VPWR VGND VPWR VGND sky130_ef_sc_hd__decap_12
X_1016_ net106 net109 net126 net123 _0340_ VGND VGND VPWR VPWR _0347_ sky130_fd_sc_hd__a41o_1
XTAP_TAPCELL_ROW_4_111 VGND VPWR sky130_fd_sc_hd__tapvpwrvgnd_1
XFILLER_17_229 VGND VGND VPWR VPWR sky130_fd_sc_hd__fill_1
XFILLER_25_251 VGND VGND VPWR VPWR sky130_fd_sc_hd__decap_3
XTAP_TAPCELL_ROW_27_213 VGND VPWR sky130_fd_sc_hd__tapvpwrvgnd_1
XTAP_TAPCELL_ROW_10_135 VGND VPWR sky130_fd_sc_hd__tapvpwrvgnd_1
XFILLER_4_122 VGND VGND VPWR VPWR sky130_fd_sc_hd__fill_2
XFILLER_31_232 VGND VGND VPWR VPWR sky130_fd_sc_hd__fill_1
XFILLER_9_225 VGND VGND VPWR VPWR sky130_fd_sc_hd__fill_1
XFILLER_13_210 VGND VGND VPWR VPWR sky130_fd_sc_hd__fill_2
X_1281_ _0605_ net116 net99 _0578_ VGND VGND VPWR VPWR _0607_ sky130_fd_sc_hd__nand4_4
X_1350_ net194 _0654_ _0672_ VGND VGND VPWR VPWR _0673_ sky130_fd_sc_hd__nand3_4
X_0996_ net185 net88 net147 net131 VGND VGND VPWR VPWR _0327_ sky130_fd_sc_hd__a22oi_4
XFILLER_40_44 VGND VGND VPWR VPWR sky130_fd_sc_hd__fill_1
XFILLER_6_239 VPWR VGND VPWR VGND sky130_ef_sc_hd__decap_12
XFILLER_10_235 VGND VGND VPWR VPWR sky130_fd_sc_hd__decap_4
XFILLER_6_3 VGND VGND VPWR VPWR sky130_fd_sc_hd__fill_1
X_0850_ net71 net49 _0204_ net50 VGND VGND VPWR VPWR _0207_ sky130_fd_sc_hd__a31o_1
X_1402_ clknet_3_2__leaf_clk _0028_ VGND VGND VPWR VPWR net56 sky130_fd_sc_hd__dfxtp_1
X_0781_ net77 net68 VGND VGND VPWR VPWR _0150_ sky130_fd_sc_hd__or2_1
XFILLER_39_3 VGND VGND VPWR VPWR sky130_fd_sc_hd__decap_4
Xinput4 a_in[3] VGND VGND VPWR VPWR net4 sky130_fd_sc_hd__clkbuf_1
X_1264_ _0588_ _0589_ _0590_ VGND VGND VPWR VPWR _0591_ sky130_fd_sc_hd__a21oi_1
X_1333_ net312 _0232_ _0657_ _0086_ VGND VGND VPWR VPWR _0055_ sky130_fd_sc_hd__o2bb2ai_1
X_1195_ _0329_ net205 net166 VGND VGND VPWR VPWR _0523_ sky130_fd_sc_hd__and3_1
X_0979_ _0307_ _0309_ _0295_ VGND VGND VPWR VPWR _0311_ sky130_fd_sc_hd__nand3b_1
XFILLER_19_34 VGND VGND VPWR VPWR sky130_fd_sc_hd__fill_2
XFILLER_19_89 VGND VGND VPWR VPWR sky130_fd_sc_hd__decap_6
XFILLER_35_11 VGND VGND VPWR VPWR sky130_fd_sc_hd__fill_2
XFILLER_2_253 VGND VGND VPWR VPWR sky130_fd_sc_hd__fill_1
XFILLER_18_121 VGND VGND VPWR VPWR sky130_fd_sc_hd__fill_1
XFILLER_33_113 VGND VGND VPWR VPWR sky130_fd_sc_hd__decap_4
X_0902_ net219 net133 net109 net112 VGND VGND VPWR VPWR _0237_ sky130_fd_sc_hd__and4_1
X_0833_ product_reg\[15\] net43 _0183_ _0194_ VGND VGND VPWR VPWR _0195_ sky130_fd_sc_hd__a211o_1
X_0764_ _0131_ _0133_ _0134_ VGND VGND VPWR VPWR _0135_ sky130_fd_sc_hd__or3_1
X_0695_ net135 VGND VGND VPWR VPWR _0075_ sky130_fd_sc_hd__inv_2
X_1247_ net105 net114 _0572_ _0573_ VGND VGND VPWR VPWR _0574_ sky130_fd_sc_hd__a22o_1
X_1316_ _0614_ _0638_ _0639_ _0609_ VGND VGND VPWR VPWR _0641_ sky130_fd_sc_hd__nand4_1
X_1178_ _0384_ _0502_ _0494_ _0499_ net152 VGND VGND VPWR VPWR _0507_ sky130_fd_sc_hd__o221ai_4
XFILLER_21_46 VGND VGND VPWR VPWR sky130_fd_sc_hd__fill_2
XFILLER_30_138 VGND VGND VPWR VPWR sky130_fd_sc_hd__fill_2
X_1101_ _0388_ _0389_ net159 _0428_ VGND VGND VPWR VPWR _0431_ sky130_fd_sc_hd__o211ai_4
X_1032_ _0075_ _0078_ _0290_ VGND VGND VPWR VPWR _0363_ sky130_fd_sc_hd__o21a_1
XTAP_TAPCELL_ROW_16_163 VGND VPWR sky130_fd_sc_hd__tapvpwrvgnd_1
XFILLER_21_116 VGND VGND VPWR VPWR sky130_fd_sc_hd__fill_2
X_0816_ product_reg\[14\] net42 VGND VGND VPWR VPWR _0180_ sky130_fd_sc_hd__nand2_1
X_0747_ _0118_ _0119_ VGND VGND VPWR VPWR _0120_ sky130_fd_sc_hd__and2_1
XTAP_TAPCELL_ROW_39_266 VGND VPWR sky130_fd_sc_hd__tapvpwrvgnd_1
XFILLER_12_138 VGND VGND VPWR VPWR sky130_fd_sc_hd__fill_2
XFILLER_32_56 VGND VGND VPWR VPWR sky130_fd_sc_hd__fill_2
XFILLER_35_219 VGND VGND VPWR VPWR sky130_fd_sc_hd__fill_1
X_1015_ _0343_ net119 net113 VGND VGND VPWR VPWR _0346_ sky130_fd_sc_hd__and3_1
XTAP_TAPCELL_ROW_4_112 VGND VPWR sky130_fd_sc_hd__tapvpwrvgnd_1
XFILLER_27_45 VGND VGND VPWR VPWR sky130_fd_sc_hd__fill_1
XFILLER_25_230 VGND VGND VPWR VPWR sky130_fd_sc_hd__fill_1
XTAP_TAPCELL_ROW_27_214 VGND VPWR sky130_fd_sc_hd__tapvpwrvgnd_1
XTAP_TAPCELL_ROW_10_136 VGND VPWR sky130_fd_sc_hd__tapvpwrvgnd_1
XFILLER_31_211 VGND VGND VPWR VPWR sky130_fd_sc_hd__decap_4
XTAP_TAPCELL_ROW_33_239 VGND VPWR sky130_fd_sc_hd__tapvpwrvgnd_1
X_1280_ _0077_ _0079_ _0576_ _0577_ _0579_ VGND VGND VPWR VPWR _0606_ sky130_fd_sc_hd__o221ai_4
X_0995_ net129 net103 VGND VGND VPWR VPWR _0326_ sky130_fd_sc_hd__nand2_2
XFILLER_39_185 VGND VGND VPWR VPWR sky130_fd_sc_hd__fill_1
XFILLER_10_247 VGND VGND VPWR VPWR sky130_fd_sc_hd__fill_2
X_0780_ _0145_ _0146_ _0147_ _0070_ VGND VGND VPWR VPWR _0149_ sky130_fd_sc_hd__a31o_1
X_1401_ clknet_3_2__leaf_clk _0027_ VGND VGND VPWR VPWR net55 sky130_fd_sc_hd__dfxtp_1
XFILLER_36_111 VGND VGND VPWR VPWR sky130_fd_sc_hd__fill_1
Xinput5 a_in[4] VGND VGND VPWR VPWR net5 sky130_fd_sc_hd__clkbuf_1
X_1194_ _0488_ _0489_ net144 _0475_ VGND VGND VPWR VPWR _0522_ sky130_fd_sc_hd__a2bb2o_1
X_1263_ _0546_ _0537_ _0539_ VGND VGND VPWR VPWR _0590_ sky130_fd_sc_hd__o21ai_1
X_1332_ _0655_ _0656_ VGND VGND VPWR VPWR _0657_ sky130_fd_sc_hd__nand2_1
X_0978_ _0307_ _0308_ _0295_ VGND VGND VPWR VPWR _0310_ sky130_fd_sc_hd__o21bai_1
XFILLER_27_177 VGND VGND VPWR VPWR sky130_fd_sc_hd__fill_1
XFILLER_42_169 VGND VGND VPWR VPWR sky130_fd_sc_hd__fill_1
XFILLER_33_169 VGND VGND VPWR VPWR sky130_fd_sc_hd__fill_1
X_0901_ net287 net84 _0085_ _0236_ VGND VGND VPWR VPWR _0044_ sky130_fd_sc_hd__a31o_1
X_0832_ _0187_ net42 product_reg\[14\] VGND VGND VPWR VPWR _0194_ sky130_fd_sc_hd__and3_1
X_0763_ _0119_ _0126_ _0125_ product_reg\[6\] net65 VGND VGND VPWR VPWR _0134_ sky130_fd_sc_hd__a32o_1
X_0694_ net129 VGND VGND VPWR VPWR _0074_ sky130_fd_sc_hd__inv_6
X_1315_ _0615_ _0638_ _0639_ VGND VGND VPWR VPWR _0640_ sky130_fd_sc_hd__and3_1
X_1246_ _0571_ net116 net102 _0526_ VGND VGND VPWR VPWR _0573_ sky130_fd_sc_hd__nand4_1
X_1177_ _0384_ _0502_ _0494_ _0499_ _0498_ VGND VGND VPWR VPWR _0506_ sky130_fd_sc_hd__o221a_4
XFILLER_15_125 VGND VGND VPWR VPWR sky130_fd_sc_hd__fill_1
X_1100_ _0325_ _0336_ _0354_ _0421_ _0420_ VGND VGND VPWR VPWR _0430_ sky130_fd_sc_hd__o2111ai_4
X_1031_ net136 net117 VGND VGND VPWR VPWR _0362_ sky130_fd_sc_hd__nand2_1
XFILLER_14_191 VGND VGND VPWR VPWR sky130_fd_sc_hd__decap_4
XTAP_TAPCELL_ROW_16_164 VGND VPWR sky130_fd_sc_hd__tapvpwrvgnd_1
X_0815_ product_reg\[14\] net42 VGND VGND VPWR VPWR _0179_ sky130_fd_sc_hd__or2_1
X_0746_ product_reg\[5\] net64 VGND VGND VPWR VPWR _0119_ sky130_fd_sc_hd__or2_1
XTAP_TAPCELL_ROW_39_267 VGND VPWR sky130_fd_sc_hd__tapvpwrvgnd_1
X_1229_ _0387_ _0501_ _0500_ VGND VGND VPWR VPWR _0557_ sky130_fd_sc_hd__o21ai_4
XFILLER_20_194 VGND VGND VPWR VPWR sky130_fd_sc_hd__fill_2
XTAP_TAPCELL_ROW_22_189 VGND VPWR sky130_fd_sc_hd__tapvpwrvgnd_1
X_1014_ net113 net119 _0342_ _0343_ VGND VGND VPWR VPWR _0345_ sky130_fd_sc_hd__a22o_1
XPHY_EDGE_ROW_14_Left_57 VGND VGND VPWR VPWR sky130_fd_sc_hd__decap_3
XFILLER_34_253 VGND VGND VPWR VPWR sky130_fd_sc_hd__fill_1
X_0729_ product_reg\[3\] net62 VGND VGND VPWR VPWR _0104_ sky130_fd_sc_hd__and2_1
XFILLER_27_24 VGND VGND VPWR VPWR sky130_fd_sc_hd__decap_8
XTAP_TAPCELL_ROW_27_215 VGND VPWR sky130_fd_sc_hd__tapvpwrvgnd_1
XTAP_TAPCELL_ROW_10_137 VGND VPWR sky130_fd_sc_hd__tapvpwrvgnd_1
XFILLER_16_253 VGND VGND VPWR VPWR sky130_fd_sc_hd__fill_1
XFILLER_13_48 VGND VGND VPWR VPWR sky130_fd_sc_hd__fill_1
XFILLER_38_89 VGND VGND VPWR VPWR sky130_fd_sc_hd__fill_1
XFILLER_13_223 VGND VGND VPWR VPWR sky130_fd_sc_hd__fill_1
X_0994_ _0299_ _0300_ _0303_ VGND VGND VPWR VPWR _0325_ sky130_fd_sc_hd__o21a_2
XPHY_EDGE_ROW_17_Left_60 VGND VGND VPWR VPWR sky130_fd_sc_hd__decap_3
X_1400_ clknet_3_3__leaf_clk _0026_ VGND VGND VPWR VPWR net54 sky130_fd_sc_hd__dfxtp_1
XFILLER_5_252 VGND VGND VPWR VPWR sky130_fd_sc_hd__fill_2
X_1331_ _0654_ net189 _0648_ _0647_ VGND VGND VPWR VPWR _0656_ sky130_fd_sc_hd__o2bb2ai_1
XFILLER_36_178 VGND VGND VPWR VPWR sky130_fd_sc_hd__fill_2
Xinput6 a_in[5] VGND VGND VPWR VPWR net6 sky130_fd_sc_hd__clkbuf_2
X_1262_ _0574_ _0575_ _0585_ _0586_ VGND VGND VPWR VPWR _0589_ sky130_fd_sc_hd__a22o_1
X_1193_ _0488_ _0489_ net145 _0475_ VGND VGND VPWR VPWR _0521_ sky130_fd_sc_hd__a2bb2oi_1
X_0977_ _0266_ _0296_ _0304_ _0305_ VGND VGND VPWR VPWR _0309_ sky130_fd_sc_hd__nand4_2
XFILLER_35_35 VGND VGND VPWR VPWR sky130_fd_sc_hd__decap_6
XFILLER_35_46 VGND VGND VPWR VPWR sky130_fd_sc_hd__decap_6
XPHY_EDGE_ROW_2_Left_45 VGND VGND VPWR VPWR sky130_fd_sc_hd__decap_3
XPHY_EDGE_ROW_14_Right_14 VGND VGND VPWR VPWR sky130_fd_sc_hd__decap_3
Xclkbuf_3_3__f_clk clknet_0_clk VGND VGND VPWR VPWR clknet_3_3__leaf_clk sky130_fd_sc_hd__clkbuf_16
XPHY_EDGE_ROW_23_Right_23 VGND VGND VPWR VPWR sky130_fd_sc_hd__decap_3
XFILLER_18_167 VGND VGND VPWR VPWR sky130_fd_sc_hd__decap_3
X_0900_ _0000_ _0234_ _0235_ VGND VGND VPWR VPWR _0236_ sky130_fd_sc_hd__and3_1
XPHY_EDGE_ROW_32_Right_32 VGND VGND VPWR VPWR sky130_fd_sc_hd__decap_3
X_0762_ _0068_ _0071_ VGND VGND VPWR VPWR _0133_ sky130_fd_sc_hd__nor2_1
X_0693_ net106 VGND VGND VPWR VPWR _0073_ sky130_fd_sc_hd__inv_2
X_0831_ product_reg\[15\] net43 _0192_ VGND VGND VPWR VPWR _0193_ sky130_fd_sc_hd__o21a_1
XPHY_EDGE_ROW_41_Right_41 VGND VGND VPWR VPWR sky130_fd_sc_hd__decap_3
X_1314_ _0636_ _0637_ _0610_ VGND VGND VPWR VPWR _0639_ sky130_fd_sc_hd__a21o_1
X_1245_ _0076_ _0079_ _0524_ _0525_ _0529_ VGND VGND VPWR VPWR _0572_ sky130_fd_sc_hd__o221ai_4
X_1176_ _0500_ net210 _0501_ _0387_ VGND VGND VPWR VPWR _0505_ sky130_fd_sc_hd__o2bb2ai_4
XFILLER_21_15 VGND VGND VPWR VPWR sky130_fd_sc_hd__decap_4
X_1030_ _0338_ _0354_ _0357_ _0353_ VGND VGND VPWR VPWR _0361_ sky130_fd_sc_hd__o211ai_4
XTAP_TAPCELL_ROW_16_165 VGND VPWR sky130_fd_sc_hd__tapvpwrvgnd_1
Xinput20 v_b_in VGND VGND VPWR VPWR net20 sky130_fd_sc_hd__clkbuf_2
X_0814_ net75 net325 net81 _0178_ VGND VGND VPWR VPWR _0014_ sky130_fd_sc_hd__o211a_1
X_0745_ product_reg\[5\] net64 VGND VGND VPWR VPWR _0118_ sky130_fd_sc_hd__nand2_1
X_1228_ _0485_ _0518_ _0551_ _0553_ VGND VGND VPWR VPWR _0556_ sky130_fd_sc_hd__o22ai_4
XFILLER_29_218 VGND VGND VPWR VPWR sky130_fd_sc_hd__decap_6
XTAP_TAPCELL_ROW_39_268 VGND VPWR sky130_fd_sc_hd__tapvpwrvgnd_1
X_1159_ _0480_ _0483_ _0484_ VGND VGND VPWR VPWR _0488_ sky130_fd_sc_hd__and3_1
XTAP_TAPCELL_ROW_7_122 VGND VPWR sky130_fd_sc_hd__tapvpwrvgnd_1
XFILLER_7_188 VGND VGND VPWR VPWR sky130_fd_sc_hd__decap_4
X_1013_ net111 net119 _0342_ _0343_ VGND VGND VPWR VPWR _0344_ sky130_fd_sc_hd__a22oi_4
X_0728_ _0098_ _0096_ _0089_ _0095_ VGND VGND VPWR VPWR _0103_ sky130_fd_sc_hd__o31ai_4
XPHY_EDGE_ROW_4_Right_4 VGND VGND VPWR VPWR sky130_fd_sc_hd__decap_3
XFILLER_4_29 VGND VGND VPWR VPWR sky130_fd_sc_hd__fill_2
XTAP_TAPCELL_ROW_10_138 VGND VPWR sky130_fd_sc_hd__tapvpwrvgnd_1
XPHY_EDGE_ROW_31_Left_74 VGND VGND VPWR VPWR sky130_fd_sc_hd__decap_3
XFILLER_16_221 VGND VGND VPWR VPWR sky130_fd_sc_hd__decap_8
XFILLER_17_91 VGND VGND VPWR VPWR sky130_fd_sc_hd__decap_8
XFILLER_9_217 VGND VGND VPWR VPWR sky130_fd_sc_hd__fill_1
XFILLER_13_235 VGND VGND VPWR VPWR sky130_fd_sc_hd__fill_2
X_0993_ _0299_ _0300_ VGND VGND VPWR VPWR _0324_ sky130_fd_sc_hd__nor2_2
XFILLER_40_36 VGND VGND VPWR VPWR sky130_fd_sc_hd__decap_8
XFILLER_6_209 VGND VGND VPWR VPWR sky130_fd_sc_hd__decap_6
XFILLER_5_220 VGND VGND VPWR VPWR sky130_fd_sc_hd__decap_4
XFILLER_14_70 VGND VGND VPWR VPWR sky130_fd_sc_hd__decap_3
XTAP_TAPCELL_ROW_1_95 VGND VPWR sky130_fd_sc_hd__tapvpwrvgnd_1
X_1261_ _0574_ _0575_ _0585_ _0586_ VGND VGND VPWR VPWR _0588_ sky130_fd_sc_hd__nand4_4
X_1330_ _0653_ _0654_ _0650_ VGND VGND VPWR VPWR _0655_ sky130_fd_sc_hd__nand3_4
Xinput7 a_in[6] VGND VGND VPWR VPWR net7 sky130_fd_sc_hd__buf_6
X_1192_ _0519_ VGND VGND VPWR VPWR _0520_ sky130_fd_sc_hd__inv_2
X_0976_ _0304_ _0305_ _0297_ VGND VGND VPWR VPWR _0308_ sky130_fd_sc_hd__and3_4
XFILLER_4_3 VGND VGND VPWR VPWR sky130_fd_sc_hd__fill_2
X_0830_ product_reg\[15\] net43 net42 product_reg\[14\] VGND VGND VPWR VPWR _0192_
+ sky130_fd_sc_hd__a211o_1
XFILLER_33_138 VGND VGND VPWR VPWR sky130_fd_sc_hd__decap_4
X_0761_ product_reg\[7\] net66 VGND VGND VPWR VPWR _0132_ sky130_fd_sc_hd__or2_1
X_0692_ net64 VGND VGND VPWR VPWR _0072_ sky130_fd_sc_hd__inv_2
X_1244_ _0076_ _0078_ _0529_ VGND VGND VPWR VPWR _0571_ sky130_fd_sc_hd__o21ai_1
X_1313_ _0078_ _0080_ _0636_ _0637_ VGND VGND VPWR VPWR _0638_ sky130_fd_sc_hd__o211ai_2
X_1175_ _0500_ net152 _0503_ VGND VGND VPWR VPWR _0504_ sky130_fd_sc_hd__a21oi_4
X_0959_ net110 net127 net124 net112 VGND VGND VPWR VPWR _0291_ sky130_fd_sc_hd__a22oi_4
XFILLER_21_38 VGND VGND VPWR VPWR sky130_fd_sc_hd__decap_8
X_0813_ _0177_ net75 _0176_ VGND VGND VPWR VPWR _0178_ sky130_fd_sc_hd__nand3b_4
Xinput10 b_in[1] VGND VGND VPWR VPWR net10 sky130_fd_sc_hd__clkbuf_2
XTAP_TAPCELL_ROW_16_166 VGND VPWR sky130_fd_sc_hd__tapvpwrvgnd_1
X_0744_ _0113_ _0110_ _0111_ VGND VGND VPWR VPWR _0117_ sky130_fd_sc_hd__o21a_1
XTAP_TAPCELL_ROW_39_269 VGND VPWR sky130_fd_sc_hd__tapvpwrvgnd_1
X_1158_ _0483_ _0484_ net113 net115 VGND VGND VPWR VPWR _0487_ sky130_fd_sc_hd__and4_2
X_1227_ _0554_ _0552_ VGND VGND VPWR VPWR _0555_ sky130_fd_sc_hd__nand2_4
X_1089_ _0414_ _0416_ VGND VGND VPWR VPWR _0419_ sky130_fd_sc_hd__nand2_1
XFILLER_16_27 VGND VGND VPWR VPWR sky130_fd_sc_hd__fill_1
XFILLER_20_174 VGND VGND VPWR VPWR sky130_fd_sc_hd__decap_6
XTAP_TAPCELL_ROW_7_123 VGND VPWR sky130_fd_sc_hd__tapvpwrvgnd_1
XFILLER_22_81 VGND VGND VPWR VPWR sky130_fd_sc_hd__decap_3
X_1012_ net106 net108 net126 net123 VGND VGND VPWR VPWR _0343_ sky130_fd_sc_hd__nand4_4
X_0727_ net76 net321 net83 _0102_ VGND VGND VPWR VPWR _0003_ sky130_fd_sc_hd__o211a_1
XTAP_TAPCELL_ROW_10_139 VGND VPWR sky130_fd_sc_hd__tapvpwrvgnd_1
XTAP_TAPCELL_ROW_35_250 VGND VPWR sky130_fd_sc_hd__tapvpwrvgnd_1
XTAP_TAPCELL_ROW_41_275 VGND VPWR sky130_fd_sc_hd__tapvpwrvgnd_1
XFILLER_33_80 VGND VGND VPWR VPWR sky130_fd_sc_hd__fill_1
XFILLER_22_247 VGND VGND VPWR VPWR sky130_fd_sc_hd__fill_1
XFILLER_0_195 VGND VGND VPWR VPWR sky130_fd_sc_hd__fill_1
X_0992_ _0275_ _0316_ _0314_ VGND VGND VPWR VPWR _0323_ sky130_fd_sc_hd__a21o_1
XFILLER_39_111 VGND VGND VPWR VPWR sky130_fd_sc_hd__fill_1
XFILLER_10_239 VGND VGND VPWR VPWR sky130_fd_sc_hd__fill_1
XFILLER_30_81 VGND VGND VPWR VPWR sky130_fd_sc_hd__decap_3
XTAP_TAPCELL_ROW_1_96 VGND VPWR sky130_fd_sc_hd__tapvpwrvgnd_1
X_1260_ _0574_ _0575_ _0585_ VGND VGND VPWR VPWR _0587_ sky130_fd_sc_hd__nand3_1
X_1191_ _0480_ _0485_ _0483_ VGND VGND VPWR VPWR _0519_ sky130_fd_sc_hd__o21ai_1
Xinput8 a_in[7] VGND VGND VPWR VPWR net8 sky130_fd_sc_hd__clkbuf_1
X_0975_ _0266_ _0296_ _0305_ _0304_ VGND VGND VPWR VPWR _0307_ sky130_fd_sc_hd__a22oi_4
X_1389_ clknet_3_2__leaf_clk _0015_ VGND VGND VPWR VPWR net42 sky130_fd_sc_hd__dfxtp_1
XFILLER_35_26 VGND VGND VPWR VPWR sky130_fd_sc_hd__decap_3
XFILLER_41_150 VGND VGND VPWR VPWR sky130_fd_sc_hd__fill_2
XFILLER_25_81 VGND VGND VPWR VPWR sky130_fd_sc_hd__fill_2
X_0760_ product_reg\[7\] net66 VGND VGND VPWR VPWR _0131_ sky130_fd_sc_hd__nor2_1
X_0691_ net66 VGND VGND VPWR VPWR _0071_ sky130_fd_sc_hd__inv_2
X_1312_ _0077_ net87 _0611_ _0079_ _0634_ VGND VGND VPWR VPWR _0637_ sky130_fd_sc_hd__o221ai_4
X_1174_ net136 net115 _0386_ _0384_ VGND VGND VPWR VPWR _0503_ sky130_fd_sc_hd__a31o_1
X_1243_ _0520_ _0553_ _0552_ VGND VGND VPWR VPWR _0570_ sky130_fd_sc_hd__o21ai_1
X_0889_ net109 net85 VGND VGND VPWR VPWR _0037_ sky130_fd_sc_hd__and2_1
X_0958_ net110 net112 net127 net124 VGND VGND VPWR VPWR _0290_ sky130_fd_sc_hd__nand4_2
XFILLER_21_28 VGND VGND VPWR VPWR sky130_fd_sc_hd__decap_4
XFILLER_23_194 VGND VGND VPWR VPWR sky130_fd_sc_hd__fill_2
XFILLER_36_80 VGND VGND VPWR VPWR sky130_fd_sc_hd__decap_4
Xinput11 b_in[2] VGND VGND VPWR VPWR net11 sky130_fd_sc_hd__clkbuf_2
X_0743_ net76 net315 net84 _0116_ VGND VGND VPWR VPWR _0005_ sky130_fd_sc_hd__o211a_1
X_0812_ _0170_ _0164_ _0173_ _0175_ VGND VGND VPWR VPWR _0177_ sky130_fd_sc_hd__and4_1
X_1157_ net113 net115 _0483_ _0484_ VGND VGND VPWR VPWR _0486_ sky130_fd_sc_hd__a22oi_4
X_1226_ _0479_ _0522_ _0547_ _0548_ _0520_ VGND VGND VPWR VPWR _0554_ sky130_fd_sc_hd__a41oi_2
X_1088_ _0410_ _0412_ net108 net119 VGND VGND VPWR VPWR _0418_ sky130_fd_sc_hd__and4_1
XFILLER_32_27 VGND VGND VPWR VPWR sky130_fd_sc_hd__fill_1
XFILLER_20_197 VPWR VGND VPWR VGND sky130_ef_sc_hd__decap_12
XTAP_TAPCELL_ROW_7_124 VGND VPWR sky130_fd_sc_hd__tapvpwrvgnd_1
XFILLER_28_231 VGND VGND VPWR VPWR sky130_fd_sc_hd__fill_1
XFILLER_28_253 VGND VGND VPWR VPWR sky130_fd_sc_hd__fill_1
XFILLER_7_135 VGND VGND VPWR VPWR sky130_fd_sc_hd__fill_2
X_1011_ net106 net126 net123 net108 VGND VGND VPWR VPWR _0342_ sky130_fd_sc_hd__a22o_2
XFILLER_21_7 VGND VGND VPWR VPWR sky130_fd_sc_hd__fill_2
X_0726_ _0100_ _0101_ net76 VGND VGND VPWR VPWR _0102_ sky130_fd_sc_hd__o21ai_1
X_1209_ _0534_ _0535_ _0536_ _0468_ VGND VGND VPWR VPWR _0537_ sky130_fd_sc_hd__a22oi_4
XTAP_TAPCELL_ROW_35_251 VGND VPWR sky130_fd_sc_hd__tapvpwrvgnd_1
XFILLER_4_149 VGND VGND VPWR VPWR sky130_fd_sc_hd__fill_1
XTAP_TAPCELL_ROW_41_276 VGND VPWR sky130_fd_sc_hd__tapvpwrvgnd_1
X_0709_ product_reg\[0\] net77 net322 VGND VGND VPWR VPWR _0087_ sky130_fd_sc_hd__a21oi_1
XFILLER_38_59 VPWR VGND VPWR VGND sky130_ef_sc_hd__decap_12
XFILLER_13_215 VGND VGND VPWR VPWR sky130_fd_sc_hd__decap_8
XFILLER_0_141 VGND VGND VPWR VPWR sky130_fd_sc_hd__fill_1
X_0991_ _0320_ _0322_ product_reg\[5\] _0232_ VGND VGND VPWR VPWR _0048_ sky130_fd_sc_hd__a2bb2o_1
XFILLER_10_218 VGND VGND VPWR VPWR sky130_fd_sc_hd__fill_2
XTAP_TAPCELL_ROW_1_97 VGND VPWR sky130_fd_sc_hd__tapvpwrvgnd_1
Xinput9 b_in[0] VGND VGND VPWR VPWR net9 sky130_fd_sc_hd__clkbuf_1
X_1190_ _0480_ _0483_ VGND VGND VPWR VPWR _0518_ sky130_fd_sc_hd__and2_1
XFILLER_36_137 VGND VGND VPWR VPWR sky130_fd_sc_hd__decap_3
X_0974_ _0304_ _0305_ VGND VGND VPWR VPWR _0306_ sky130_fd_sc_hd__nand2_1
X_1388_ clknet_3_2__leaf_clk _0014_ VGND VGND VPWR VPWR net41 sky130_fd_sc_hd__dfxtp_1
X_0690_ net76 VGND VGND VPWR VPWR _0070_ sky130_fd_sc_hd__inv_2
X_1311_ _0635_ net114 net99 VGND VGND VPWR VPWR _0636_ sky130_fd_sc_hd__nand3_1
XPHY_EDGE_ROW_10_Right_10 VGND VGND VPWR VPWR sky130_fd_sc_hd__decap_3
X_1173_ _0386_ net115 net136 VGND VGND VPWR VPWR _0502_ sky130_fd_sc_hd__and3_1
X_1242_ _0561_ net208 _0558_ VGND VGND VPWR VPWR _0569_ sky130_fd_sc_hd__a21o_1
XTAP_TAPCELL_ROW_19_176 VGND VPWR sky130_fd_sc_hd__tapvpwrvgnd_1
X_0888_ net111 net85 VGND VGND VPWR VPWR _0036_ sky130_fd_sc_hd__and2_1
X_0957_ net110 net112 net127 net123 VGND VGND VPWR VPWR _0289_ sky130_fd_sc_hd__and4_1
XPHY_EDGE_ROW_6_Left_49 VGND VGND VPWR VPWR sky130_fd_sc_hd__decap_3
XFILLER_23_140 VGND VGND VPWR VPWR sky130_fd_sc_hd__fill_1
XFILLER_14_195 VGND VGND VPWR VPWR sky130_fd_sc_hd__fill_1
Xinput12 b_in[3] VGND VGND VPWR VPWR net12 sky130_fd_sc_hd__clkbuf_1
X_0742_ _0114_ _0115_ _0070_ VGND VGND VPWR VPWR _0116_ sky130_fd_sc_hd__a21o_1
X_0811_ _0164_ _0170_ _0173_ _0175_ VGND VGND VPWR VPWR _0176_ sky130_fd_sc_hd__a22o_1
XFILLER_42_3 VGND VGND VPWR VPWR sky130_fd_sc_hd__decap_4
X_1087_ net108 net119 _0409_ _0411_ VGND VGND VPWR VPWR _0417_ sky130_fd_sc_hd__o2bb2a_2
X_1225_ _0492_ net141 _0549_ _0550_ VGND VGND VPWR VPWR _0553_ sky130_fd_sc_hd__a22oi_4
X_1156_ _0484_ VGND VGND VPWR VPWR _0485_ sky130_fd_sc_hd__inv_2
XTAP_TAPCELL_ROW_7_125 VGND VPWR sky130_fd_sc_hd__tapvpwrvgnd_1
XFILLER_7_169 VGND VGND VPWR VPWR sky130_fd_sc_hd__fill_2
XTAP_TAPCELL_ROW_13_149 VGND VPWR sky130_fd_sc_hd__tapvpwrvgnd_1
X_1010_ net106 net126 net123 net108 VGND VGND VPWR VPWR _0341_ sky130_fd_sc_hd__a22oi_4
XFILLER_19_221 VGND VGND VPWR VPWR sky130_fd_sc_hd__decap_3
X_0725_ _0090_ _0095_ _0097_ _0099_ VGND VGND VPWR VPWR _0101_ sky130_fd_sc_hd__and4_1
X_1208_ _0455_ _0458_ net164 VGND VGND VPWR VPWR _0536_ sky130_fd_sc_hd__o21ai_4
X_1139_ _0395_ net192 _0459_ _0462_ _0399_ VGND VGND VPWR VPWR _0468_ sky130_fd_sc_hd__o221ai_4
XPHY_EDGE_ROW_9_Left_52 VGND VGND VPWR VPWR sky130_fd_sc_hd__decap_3
XTAP_TAPCELL_ROW_41_277 VGND VPWR sky130_fd_sc_hd__tapvpwrvgnd_1
XFILLER_31_205 VGND VGND VPWR VPWR sky130_fd_sc_hd__decap_3
XPHY_EDGE_ROW_8_Right_8 VGND VGND VPWR VPWR sky130_fd_sc_hd__decap_3
XPHY_EDGE_ROW_39_Right_39 VGND VGND VPWR VPWR sky130_fd_sc_hd__decap_3
X_0708_ _0086_ VGND VGND VPWR VPWR _0000_ sky130_fd_sc_hd__inv_2
XPHY_EDGE_ROW_35_Left_78 VGND VGND VPWR VPWR sky130_fd_sc_hd__decap_3
XFILLER_28_82 VGND VGND VPWR VPWR sky130_fd_sc_hd__fill_2
XFILLER_8_253 VGND VGND VPWR VPWR sky130_fd_sc_hd__fill_1
X_0990_ _0281_ _0284_ _0319_ _0086_ VGND VGND VPWR VPWR _0322_ sky130_fd_sc_hd__a31o_1
XFILLER_39_124 VGND VGND VPWR VPWR sky130_fd_sc_hd__decap_3
XFILLER_14_40 VGND VGND VPWR VPWR sky130_fd_sc_hd__fill_1
XFILLER_14_62 VGND VGND VPWR VPWR sky130_fd_sc_hd__decap_8
XTAP_TAPCELL_ROW_1_98 VGND VPWR sky130_fd_sc_hd__tapvpwrvgnd_1
XFILLER_36_105 VGND VGND VPWR VPWR sky130_fd_sc_hd__decap_6
X_0973_ _0301_ _0303_ net107 net129 VGND VGND VPWR VPWR _0305_ sky130_fd_sc_hd__nand4_4
X_1387_ clknet_3_2__leaf_clk _0013_ VGND VGND VPWR VPWR net40 sky130_fd_sc_hd__dfxtp_1
XFILLER_18_138 VGND VGND VPWR VPWR sky130_fd_sc_hd__fill_2
Xrebuffer90 _0438_ VGND VGND VPWR VPWR net226 sky130_fd_sc_hd__buf_6
XFILLER_25_50 VGND VGND VPWR VPWR sky130_fd_sc_hd__fill_1
XPHY_EDGE_ROW_38_Left_81 VGND VGND VPWR VPWR sky130_fd_sc_hd__decap_3
X_1310_ _0079_ _0611_ _0634_ VGND VGND VPWR VPWR _0635_ sky130_fd_sc_hd__o21ai_1
XPHY_EDGE_ROW_22_Left_65 VGND VGND VPWR VPWR sky130_fd_sc_hd__decap_3
X_1241_ net169 _0510_ _0561_ VGND VGND VPWR VPWR _0568_ sky130_fd_sc_hd__o21ai_2
XTAP_TAPCELL_ROW_19_177 VGND VPWR sky130_fd_sc_hd__tapvpwrvgnd_1
X_1172_ _0075_ _0081_ _0385_ VGND VGND VPWR VPWR _0501_ sky130_fd_sc_hd__o21a_1
X_0956_ _0263_ _0268_ _0269_ _0273_ _0278_ VGND VGND VPWR VPWR _0288_ sky130_fd_sc_hd__a32o_1
X_0887_ _0075_ net79 VGND VGND VPWR VPWR _0035_ sky130_fd_sc_hd__nor2_1
X_1439_ clknet_3_0__leaf_clk _0065_ VGND VGND VPWR VPWR net35 sky130_fd_sc_hd__dfxtp_1
Xinput13 b_in[4] VGND VGND VPWR VPWR net13 sky130_fd_sc_hd__clkbuf_1
X_0810_ product_reg\[13\] net41 VGND VGND VPWR VPWR _0175_ sky130_fd_sc_hd__nand2_1
X_0741_ _0113_ _0110_ VGND VGND VPWR VPWR _0115_ sky130_fd_sc_hd__or2_1
X_1224_ _0478_ _0521_ _0547_ _0548_ VGND VGND VPWR VPWR _0552_ sky130_fd_sc_hd__a2bb2o_4
X_1155_ _0408_ _0409_ _0412_ _0481_ VGND VGND VPWR VPWR _0484_ sky130_fd_sc_hd__o211ai_4
X_1086_ _0409_ _0411_ _0408_ VGND VGND VPWR VPWR _0416_ sky130_fd_sc_hd__o21bai_1
X_0939_ _0263_ _0268_ _0269_ VGND VGND VPWR VPWR _0272_ sky130_fd_sc_hd__nand3_1
XFILLER_32_29 VGND VGND VPWR VPWR sky130_fd_sc_hd__decap_3
XTAP_TAPCELL_ROW_38_261 VGND VPWR sky130_fd_sc_hd__tapvpwrvgnd_1
X_0724_ _0095_ _0097_ _0098_ _0089_ VGND VGND VPWR VPWR _0100_ sky130_fd_sc_hd__o2bb2a_1
X_1207_ _0532_ _0533_ _0523_ VGND VGND VPWR VPWR _0535_ sky130_fd_sc_hd__nand3_4
X_1138_ _0460_ _0463_ _0465_ _0397_ VGND VGND VPWR VPWR _0467_ sky130_fd_sc_hd__a22oi_4
X_1069_ net183 net134 net96 net204 VGND VGND VPWR VPWR _0399_ sky130_fd_sc_hd__nand4_4
XTAP_TAPCELL_ROW_41_278 VGND VPWR sky130_fd_sc_hd__tapvpwrvgnd_1
XFILLER_33_50 VGND VGND VPWR VPWR sky130_fd_sc_hd__fill_1
XFILLER_22_206 VGND VGND VPWR VPWR sky130_fd_sc_hd__fill_1
XFILLER_22_228 VGND VGND VPWR VPWR sky130_fd_sc_hd__fill_2
XTAP_TAPCELL_ROW_32_234 VGND VPWR sky130_fd_sc_hd__tapvpwrvgnd_1
X_0707_ net17 net18 _0085_ VGND VGND VPWR VPWR _0086_ sky130_fd_sc_hd__or3_2
XFILLER_10_209 VGND VGND VPWR VPWR sky130_fd_sc_hd__fill_2
XFILLER_24_19 VGND VGND VPWR VPWR sky130_fd_sc_hd__fill_2
XFILLER_14_85 VGND VGND VPWR VPWR sky130_fd_sc_hd__fill_1
XFILLER_30_73 VGND VGND VPWR VPWR sky130_fd_sc_hd__decap_8
X_0972_ _0073_ _0074_ _0300_ _0302_ VGND VGND VPWR VPWR _0304_ sky130_fd_sc_hd__o22ai_4
X_1386_ clknet_3_3__leaf_clk _0012_ VGND VGND VPWR VPWR net39 sky130_fd_sc_hd__dfxtp_1
XFILLER_35_18 VGND VGND VPWR VPWR sky130_fd_sc_hd__decap_8
Xrebuffer80 net97 VGND VGND VPWR VPWR net216 sky130_fd_sc_hd__dlygate4sd1_1
Xrebuffer91 _0438_ VGND VGND VPWR VPWR net227 sky130_fd_sc_hd__buf_1
Xrebuffer170 net307 VGND VGND VPWR VPWR net306 sky130_fd_sc_hd__dlygate4sd1_1
X_1171_ _0392_ net140 _0430_ _0495_ _0496_ VGND VGND VPWR VPWR _0500_ sky130_fd_sc_hd__o2111ai_4
X_1240_ _0562_ net157 _0514_ net179 VGND VGND VPWR VPWR _0567_ sky130_fd_sc_hd__nand4_4
XTAP_TAPCELL_ROW_19_178 VGND VPWR sky130_fd_sc_hd__tapvpwrvgnd_1
X_0955_ _0263_ _0268_ _0269_ _0273_ _0278_ VGND VGND VPWR VPWR _0287_ sky130_fd_sc_hd__a32oi_2
X_0886_ net19 net81 VGND VGND VPWR VPWR _0033_ sky130_fd_sc_hd__and2_1
X_1369_ net127 net85 VGND VGND VPWR VPWR _0062_ sky130_fd_sc_hd__and2_1
X_1438_ clknet_3_5__leaf_clk _0064_ VGND VGND VPWR VPWR net34 sky130_fd_sc_hd__dfxtp_1
Xinput14 b_in[5] VGND VGND VPWR VPWR net14 sky130_fd_sc_hd__clkbuf_1
X_0740_ net282 _0106_ _0111_ _0112_ _0104_ VGND VGND VPWR VPWR _0114_ sky130_fd_sc_hd__a221o_1
X_1154_ _0482_ net117 net108 _0410_ VGND VGND VPWR VPWR _0483_ sky130_fd_sc_hd__nand4_4
X_1223_ _0478_ _0521_ _0547_ _0548_ VGND VGND VPWR VPWR _0551_ sky130_fd_sc_hd__a2bb2oi_4
X_1085_ _0409_ _0411_ net108 net119 VGND VGND VPWR VPWR _0415_ sky130_fd_sc_hd__o211a_1
X_0869_ net55 net72 net74 _0216_ net308 VGND VGND VPWR VPWR _0220_ sky130_fd_sc_hd__a41oi_1
X_0938_ net107 net89 net132 net103 _0264_ VGND VGND VPWR VPWR _0271_ sky130_fd_sc_hd__a41o_1
XFILLER_20_167 VGND VGND VPWR VPWR sky130_fd_sc_hd__fill_2
XTAP_TAPCELL_ROW_38_262 VGND VPWR sky130_fd_sc_hd__tapvpwrvgnd_1
XFILLER_11_167 VGND VGND VPWR VPWR sky130_fd_sc_hd__fill_1
XFILLER_22_96 VPWR VGND VPWR VGND sky130_ef_sc_hd__decap_12
XFILLER_19_201 VGND VGND VPWR VPWR sky130_fd_sc_hd__decap_4
XFILLER_19_245 VGND VGND VPWR VPWR sky130_fd_sc_hd__fill_1
X_0723_ net288 net284 net37 product_reg\[0\] VGND VGND VPWR VPWR _0099_ sky130_fd_sc_hd__a22o_1
XTAP_TAPCELL_ROW_4_108 VGND VPWR sky130_fd_sc_hd__tapvpwrvgnd_1
X_1206_ _0523_ _0530_ _0531_ VGND VGND VPWR VPWR _0534_ sky130_fd_sc_hd__nand3b_4
X_1137_ _0397_ net100 net167 net180 VGND VGND VPWR VPWR _0466_ sky130_fd_sc_hd__a31o_1
X_1068_ net96 net134 net183 net92 VGND VGND VPWR VPWR _0398_ sky130_fd_sc_hd__and4_4
XTAP_TAPCELL_ROW_26_210 VGND VPWR sky130_fd_sc_hd__tapvpwrvgnd_1
XFILLER_3_130 VGND VGND VPWR VPWR sky130_fd_sc_hd__fill_2
XTAP_TAPCELL_ROW_32_235 VGND VPWR sky130_fd_sc_hd__tapvpwrvgnd_1
X_0706_ net20 net81 VGND VGND VPWR VPWR _0034_ sky130_fd_sc_hd__and2_1
XFILLER_38_29 VGND VGND VPWR VPWR sky130_fd_sc_hd__decap_3
XFILLER_0_111 VGND VGND VPWR VPWR sky130_fd_sc_hd__fill_1
XFILLER_40_19 VGND VGND VPWR VPWR sky130_fd_sc_hd__fill_1
Xhold200 net50 VGND VGND VPWR VPWR net336 sky130_fd_sc_hd__dlygate4sd3_1
XFILLER_5_247 VGND VGND VPWR VPWR sky130_fd_sc_hd__fill_1
XFILLER_5_225 VGND VGND VPWR VPWR sky130_fd_sc_hd__fill_2
XFILLER_30_41 VPWR VGND VPWR VGND sky130_ef_sc_hd__decap_12
XFILLER_30_63 VGND VGND VPWR VPWR sky130_fd_sc_hd__fill_2
XFILLER_30_96 VGND VGND VPWR VPWR sky130_fd_sc_hd__decap_8
XFILLER_36_129 VGND VGND VPWR VPWR sky130_fd_sc_hd__decap_8
X_0971_ net198 net131 net104 net148 VGND VGND VPWR VPWR _0303_ sky130_fd_sc_hd__nand4_2
X_1385_ clknet_3_6__leaf_clk _0011_ VGND VGND VPWR VPWR net38 sky130_fd_sc_hd__dfxtp_1
Xrebuffer70 _0427_ VGND VGND VPWR VPWR net206 sky130_fd_sc_hd__clkbuf_1
Xrebuffer81 net97 VGND VGND VPWR VPWR net217 sky130_fd_sc_hd__dlygate4sd1_1
Xrebuffer92 _0407_ VGND VGND VPWR VPWR net228 sky130_fd_sc_hd__dlygate4sd1_1
Xrebuffer171 product_reg\[1\] VGND VGND VPWR VPWR net307 sky130_fd_sc_hd__dlymetal6s4s_1
Xrebuffer160 net48 VGND VGND VPWR VPWR net296 sky130_fd_sc_hd__dlymetal6s2s_1
X_1170_ _0392_ net225 net158 _0496_ VGND VGND VPWR VPWR _0499_ sky130_fd_sc_hd__o211ai_4
XTAP_TAPCELL_ROW_19_179 VGND VPWR sky130_fd_sc_hd__tapvpwrvgnd_1
X_0885_ net314 _0230_ net81 _0231_ VGND VGND VPWR VPWR _0032_ sky130_fd_sc_hd__o211a_1
X_0954_ net78 _0285_ _0286_ VGND VGND VPWR VPWR _0047_ sky130_fd_sc_hd__a21oi_1
XFILLER_32_187 VGND VGND VPWR VPWR sky130_fd_sc_hd__decap_6
X_1437_ clknet_3_5__leaf_clk _0063_ VGND VGND VPWR VPWR net33 sky130_fd_sc_hd__dfxtp_1
X_1368_ _0074_ net79 VGND VGND VPWR VPWR _0061_ sky130_fd_sc_hd__nor2_1
X_1299_ _0623_ _0622_ _0621_ VGND VGND VPWR VPWR _0625_ sky130_fd_sc_hd__nand3_1
XFILLER_14_154 VGND VGND VPWR VPWR sky130_fd_sc_hd__decap_3
Xinput15 b_in[6] VGND VGND VPWR VPWR net15 sky130_fd_sc_hd__buf_1
X_1084_ _0408_ _0410_ _0412_ VGND VGND VPWR VPWR _0414_ sky130_fd_sc_hd__nand3_1
X_1153_ _0408_ _0412_ VGND VGND VPWR VPWR _0482_ sky130_fd_sc_hd__nand2_1
X_1222_ _0537_ _0539_ _0544_ _0545_ VGND VGND VPWR VPWR _0550_ sky130_fd_sc_hd__nand4b_1
XTAP_TAPCELL_ROW_15_160 VGND VPWR sky130_fd_sc_hd__tapvpwrvgnd_1
X_0868_ net340 _0218_ _0219_ net82 VGND VGND VPWR VPWR _0027_ sky130_fd_sc_hd__o211a_1
X_0937_ net109 net129 _0266_ _0267_ VGND VGND VPWR VPWR _0270_ sky130_fd_sc_hd__a22o_1
X_0799_ _0163_ _0164_ VGND VGND VPWR VPWR _0165_ sky130_fd_sc_hd__and2_1
XTAP_TAPCELL_ROW_38_263 VGND VPWR sky130_fd_sc_hd__tapvpwrvgnd_1
XTAP_TAPCELL_ROW_21_185 VGND VPWR sky130_fd_sc_hd__tapvpwrvgnd_1
XFILLER_22_75 VGND VGND VPWR VPWR sky130_fd_sc_hd__fill_2
Xclkbuf_3_4__f_clk clknet_0_clk VGND VGND VPWR VPWR clknet_3_4__leaf_clk sky130_fd_sc_hd__clkbuf_16
X_0722_ net48 product_reg\[1\] net37 product_reg\[0\] VGND VGND VPWR VPWR _0098_ sky130_fd_sc_hd__a22oi_4
XFILLER_6_194 VGND VGND VPWR VPWR sky130_fd_sc_hd__fill_2
XTAP_TAPCELL_ROW_4_109 VGND VPWR sky130_fd_sc_hd__tapvpwrvgnd_1
X_1136_ _0395_ _0399_ VGND VGND VPWR VPWR _0465_ sky130_fd_sc_hd__nand2_4
X_1067_ net95 net134 net204 net183 VGND VGND VPWR VPWR _0397_ sky130_fd_sc_hd__a22o_4
X_1205_ _0526_ _0529_ net102 net118 VGND VGND VPWR VPWR _0533_ sky130_fd_sc_hd__nand4_2
XFILLER_17_42 VGND VGND VPWR VPWR sky130_fd_sc_hd__fill_1
XTAP_TAPCELL_ROW_26_211 VGND VPWR sky130_fd_sc_hd__tapvpwrvgnd_1
XFILLER_33_96 VGND VGND VPWR VPWR sky130_fd_sc_hd__fill_2
XTAP_TAPCELL_ROW_32_236 VGND VPWR sky130_fd_sc_hd__tapvpwrvgnd_1
X_0705_ net20 net19 VGND VGND VPWR VPWR _0085_ sky130_fd_sc_hd__nand2_2
X_1119_ _0321_ _0377_ _0445_ VGND VGND VPWR VPWR _0449_ sky130_fd_sc_hd__or3_1
XPHY_EDGE_ROW_17_Right_17 VGND VGND VPWR VPWR sky130_fd_sc_hd__decap_3
XPHY_EDGE_ROW_26_Right_26 VGND VGND VPWR VPWR sky130_fd_sc_hd__decap_3
XFILLER_28_74 VGND VGND VPWR VPWR sky130_fd_sc_hd__decap_8
XFILLER_28_85 VGND VGND VPWR VPWR sky130_fd_sc_hd__fill_1
XPHY_EDGE_ROW_35_Right_35 VGND VGND VPWR VPWR sky130_fd_sc_hd__decap_3
Xhold201 net60 VGND VGND VPWR VPWR net337 sky130_fd_sc_hd__dlygate4sd3_1
XFILLER_30_53 VGND VGND VPWR VPWR sky130_fd_sc_hd__decap_3
X_0970_ net196 net131 net104 net147 VGND VGND VPWR VPWR _0302_ sky130_fd_sc_hd__and4_4
X_1384_ clknet_3_6__leaf_clk _0010_ VGND VGND VPWR VPWR net68 sky130_fd_sc_hd__dfxtp_2
Xrebuffer60 net88 VGND VGND VPWR VPWR net196 sky130_fd_sc_hd__dlymetal6s2s_1
Xrebuffer71 _0427_ VGND VGND VPWR VPWR net207 sky130_fd_sc_hd__buf_6
Xrebuffer82 net217 VGND VGND VPWR VPWR net218 sky130_fd_sc_hd__dlygate4sd1_1
XFILLER_25_20 VGND VGND VPWR VPWR sky130_fd_sc_hd__fill_1
Xrebuffer93 _0563_ VGND VGND VPWR VPWR net229 sky130_fd_sc_hd__buf_1
Xrebuffer150 net48 VGND VGND VPWR VPWR net286 sky130_fd_sc_hd__dlygate4sd1_1
XFILLER_17_185 VGND VGND VPWR VPWR sky130_fd_sc_hd__fill_1
X_0884_ _0227_ net337 net314 VGND VGND VPWR VPWR _0231_ sky130_fd_sc_hd__nand3_2
X_0953_ net317 net78 net84 VGND VGND VPWR VPWR _0286_ sky130_fd_sc_hd__o21ai_1
X_1436_ clknet_3_5__leaf_clk _0062_ VGND VGND VPWR VPWR net32 sky130_fd_sc_hd__dfxtp_1
X_1367_ net133 net85 VGND VGND VPWR VPWR _0060_ sky130_fd_sc_hd__and2_1
X_1298_ _0621_ _0622_ _0623_ VGND VGND VPWR VPWR _0624_ sky130_fd_sc_hd__a21oi_1
XFILLER_23_111 VGND VGND VPWR VPWR sky130_fd_sc_hd__fill_1
XFILLER_11_66 VGND VGND VPWR VPWR sky130_fd_sc_hd__fill_1
XFILLER_36_85 VGND VGND VPWR VPWR sky130_fd_sc_hd__decap_4
XFILLER_36_63 VGND VGND VPWR VPWR sky130_fd_sc_hd__fill_1
XFILLER_36_41 VPWR VGND VPWR VGND sky130_ef_sc_hd__decap_12
XPHY_EDGE_ROW_26_Left_69 VGND VGND VPWR VPWR sky130_fd_sc_hd__decap_3
Xinput16 b_in[7] VGND VGND VPWR VPWR net16 sky130_fd_sc_hd__clkbuf_1
XFILLER_42_7 VGND VGND VPWR VPWR sky130_fd_sc_hd__fill_1
X_1221_ _0537_ _0538_ _0546_ VGND VGND VPWR VPWR _0549_ sky130_fd_sc_hd__o21ai_1
X_1152_ net108 net117 VGND VGND VPWR VPWR _0481_ sky130_fd_sc_hd__nand2_1
X_1083_ _0408_ _0410_ _0412_ VGND VGND VPWR VPWR _0413_ sky130_fd_sc_hd__and3_1
X_0936_ _0266_ _0267_ _0264_ VGND VGND VPWR VPWR _0269_ sky130_fd_sc_hd__a21o_1
XTAP_TAPCELL_ROW_15_161 VGND VPWR sky130_fd_sc_hd__tapvpwrvgnd_1
X_0867_ net339 net298 net74 _0216_ VGND VGND VPWR VPWR _0219_ sky130_fd_sc_hd__nand4_1
X_0798_ product_reg\[12\] net40 VGND VGND VPWR VPWR _0164_ sky130_fd_sc_hd__nand2_1
X_1419_ clknet_3_4__leaf_clk _0045_ VGND VGND VPWR VPWR product_reg\[2\] sky130_fd_sc_hd__dfxtp_1
XTAP_TAPCELL_ROW_38_264 VGND VPWR sky130_fd_sc_hd__tapvpwrvgnd_1
XFILLER_11_169 VGND VGND VPWR VPWR sky130_fd_sc_hd__decap_3
XTAP_TAPCELL_ROW_21_186 VGND VPWR sky130_fd_sc_hd__tapvpwrvgnd_1
XFILLER_0_3 VGND VGND VPWR VPWR sky130_fd_sc_hd__fill_1
XFILLER_42_250 VGND VGND VPWR VPWR sky130_fd_sc_hd__fill_2
XFILLER_6_173 VGND VGND VPWR VPWR sky130_fd_sc_hd__fill_1
XFILLER_10_191 VGND VGND VPWR VPWR sky130_fd_sc_hd__decap_4
X_0721_ product_reg\[2\] net59 VGND VGND VPWR VPWR _0097_ sky130_fd_sc_hd__or2_1
X_1204_ _0076_ _0078_ _0525_ _0528_ VGND VGND VPWR VPWR _0532_ sky130_fd_sc_hd__o22ai_2
X_1135_ _0074_ _0080_ _0329_ _0460_ VGND VGND VPWR VPWR _0464_ sky130_fd_sc_hd__o31a_1
X_1066_ net134 net185 net183 net92 VGND VGND VPWR VPWR _0396_ sky130_fd_sc_hd__a22oi_4
X_0919_ _0250_ _0251_ _0252_ VGND VGND VPWR VPWR _0253_ sky130_fd_sc_hd__a21oi_2
XFILLER_33_31 VGND VGND VPWR VPWR sky130_fd_sc_hd__fill_2
XTAP_TAPCELL_ROW_40_270 VGND VPWR sky130_fd_sc_hd__tapvpwrvgnd_1
XPHY_EDGE_ROW_29_Left_72 VGND VGND VPWR VPWR sky130_fd_sc_hd__decap_3
XFILLER_30_231 VGND VGND VPWR VPWR sky130_fd_sc_hd__fill_1
XFILLER_30_253 VGND VGND VPWR VPWR sky130_fd_sc_hd__fill_1
XTAP_TAPCELL_ROW_32_237 VGND VPWR sky130_fd_sc_hd__tapvpwrvgnd_1
XPHY_EDGE_ROW_13_Left_56 VGND VGND VPWR VPWR sky130_fd_sc_hd__decap_3
X_0704_ net20 net19 VGND VGND VPWR VPWR _0084_ sky130_fd_sc_hd__and2_1
X_1118_ _0442_ _0446_ _0445_ VGND VGND VPWR VPWR _0448_ sky130_fd_sc_hd__o21bai_1
X_1049_ _0378_ _0379_ _0000_ _0232_ net311 VGND VGND VPWR VPWR _0049_ sky130_fd_sc_hd__a32o_1
XFILLER_8_246 VGND VGND VPWR VPWR sky130_fd_sc_hd__decap_6
XFILLER_12_253 VGND VGND VPWR VPWR sky130_fd_sc_hd__fill_1
XFILLER_5_57 VGND VGND VPWR VPWR sky130_fd_sc_hd__fill_1
Xhold202 net55 VGND VGND VPWR VPWR net338 sky130_fd_sc_hd__dlygate4sd3_1
XFILLER_38_194 VGND VGND VPWR VPWR sky130_fd_sc_hd__fill_2
XFILLER_38_183 VGND VGND VPWR VPWR sky130_fd_sc_hd__fill_2
XFILLER_38_172 VGND VGND VPWR VPWR sky130_fd_sc_hd__fill_2
XFILLER_39_74 VGND VGND VPWR VPWR sky130_fd_sc_hd__decap_3
X_1383_ clknet_3_6__leaf_clk _0009_ VGND VGND VPWR VPWR net67 sky130_fd_sc_hd__dfxtp_1
XFILLER_35_131 VGND VGND VPWR VPWR sky130_fd_sc_hd__fill_1
Xrebuffer61 net88 VGND VGND VPWR VPWR net197 sky130_fd_sc_hd__buf_1
Xrebuffer50 net185 VGND VGND VPWR VPWR net186 sky130_fd_sc_hd__buf_2
Xrebuffer83 net90 VGND VGND VPWR VPWR net219 sky130_fd_sc_hd__dlygate4sd1_1
XFILLER_25_54 VGND VGND VPWR VPWR sky130_fd_sc_hd__fill_2
XFILLER_26_164 VGND VGND VPWR VPWR sky130_fd_sc_hd__fill_2
XFILLER_26_197 VGND VGND VPWR VPWR sky130_fd_sc_hd__decap_3
Xrebuffer72 _0511_ VGND VGND VPWR VPWR net208 sky130_fd_sc_hd__clkbuf_2
Xrebuffer151 net303 VGND VGND VPWR VPWR net287 sky130_fd_sc_hd__dlygate4sd1_1
XFILLER_1_252 VGND VGND VPWR VPWR sky130_fd_sc_hd__fill_2
XFILLER_17_120 VGND VGND VPWR VPWR sky130_fd_sc_hd__fill_2
X_0952_ _0258_ _0283_ VGND VGND VPWR VPWR _0285_ sky130_fd_sc_hd__xnor2_1
XFILLER_32_178 VGND VGND VPWR VPWR sky130_fd_sc_hd__decap_3
X_0883_ net79 _0230_ _0229_ VGND VGND VPWR VPWR _0031_ sky130_fd_sc_hd__nor3b_1
X_1435_ clknet_3_5__leaf_clk _0061_ VGND VGND VPWR VPWR net31 sky130_fd_sc_hd__dfxtp_1
X_1366_ net223 net85 VGND VGND VPWR VPWR _0059_ sky130_fd_sc_hd__and2_1
X_1297_ _0595_ _0591_ _0594_ VGND VGND VPWR VPWR _0623_ sky130_fd_sc_hd__o21ai_1
XFILLER_36_53 VGND VGND VPWR VPWR sky130_fd_sc_hd__decap_4
XPHY_EDGE_ROW_1_Left_44 VGND VGND VPWR VPWR sky130_fd_sc_hd__decap_3
Xinput17 clear_acc VGND VGND VPWR VPWR net17 sky130_fd_sc_hd__clkbuf_2
X_1220_ _0537_ _0539_ _0546_ VGND VGND VPWR VPWR _0548_ sky130_fd_sc_hd__nand3b_2
X_1151_ net113 net115 VGND VGND VPWR VPWR _0480_ sky130_fd_sc_hd__nand2_1
X_1082_ net107 net125 net102 net122 VGND VGND VPWR VPWR _0412_ sky130_fd_sc_hd__nand4_4
X_0866_ net72 net74 _0216_ VGND VGND VPWR VPWR _0218_ sky130_fd_sc_hd__and3_1
X_0935_ _0264_ _0266_ _0267_ VGND VGND VPWR VPWR _0268_ sky130_fd_sc_hd__nand3_1
X_0797_ product_reg\[12\] net40 VGND VGND VPWR VPWR _0163_ sky130_fd_sc_hd__or2_1
X_1349_ _0667_ _0648_ _0665_ _0647_ VGND VGND VPWR VPWR _0672_ sky130_fd_sc_hd__nor4_2
X_1418_ clknet_3_4__leaf_clk _0044_ VGND VGND VPWR VPWR product_reg\[1\] sky130_fd_sc_hd__dfxtp_2
XTAP_TAPCELL_ROW_38_265 VGND VPWR sky130_fd_sc_hd__tapvpwrvgnd_1
XTAP_TAPCELL_ROW_21_187 VGND VPWR sky130_fd_sc_hd__tapvpwrvgnd_1
XFILLER_19_237 VGND VGND VPWR VPWR sky130_fd_sc_hd__decap_8
XTAP_TAPCELL_ROW_29_221 VGND VPWR sky130_fd_sc_hd__tapvpwrvgnd_1
X_0720_ product_reg\[2\] net59 VGND VGND VPWR VPWR _0096_ sky130_fd_sc_hd__nor2_1
X_1203_ _0525_ _0528_ _0524_ VGND VGND VPWR VPWR _0531_ sky130_fd_sc_hd__o21bai_2
X_1134_ net134 net165 net95 net92 VGND VGND VPWR VPWR _0463_ sky130_fd_sc_hd__nand4_4
X_1065_ net130 net100 VGND VGND VPWR VPWR _0395_ sky130_fd_sc_hd__nand2_4
X_0849_ net49 net297 _0204_ net80 _0206_ VGND VGND VPWR VPWR _0021_ sky130_fd_sc_hd__a311oi_1
X_0918_ _0239_ net135 net168 _0237_ VGND VGND VPWR VPWR _0252_ sky130_fd_sc_hd__a31o_1
XFILLER_16_229 VGND VGND VPWR VPWR sky130_fd_sc_hd__fill_2
XFILLER_17_55 VGND VGND VPWR VPWR sky130_fd_sc_hd__fill_1
XFILLER_17_99 VGND VGND VPWR VPWR sky130_fd_sc_hd__fill_1
XTAP_TAPCELL_ROW_32_238 VGND VPWR sky130_fd_sc_hd__tapvpwrvgnd_1
XTAP_TAPCELL_ROW_40_271 VGND VPWR sky130_fd_sc_hd__tapvpwrvgnd_1
X_0703_ net17 net18 VGND VGND VPWR VPWR _0083_ sky130_fd_sc_hd__or2_1
X_1117_ _0440_ _0443_ _0375_ VGND VGND VPWR VPWR _0447_ sky130_fd_sc_hd__nand3_4
XPHY_EDGE_ROW_3_Right_3 VGND VGND VPWR VPWR sky130_fd_sc_hd__decap_3
X_1048_ _0320_ _0376_ _0374_ VGND VGND VPWR VPWR _0379_ sky130_fd_sc_hd__nand3_4
XPHY_EDGE_ROW_30_Left_73 VGND VGND VPWR VPWR sky130_fd_sc_hd__decap_3
Xhold203 net55 VGND VGND VPWR VPWR net339 sky130_fd_sc_hd__dlygate4sd3_1
XFILLER_14_78 VGND VGND VPWR VPWR sky130_fd_sc_hd__fill_1
XFILLER_5_239 VGND VGND VPWR VPWR sky130_fd_sc_hd__decap_8
X_1382_ clknet_3_7__leaf_clk _0008_ VGND VGND VPWR VPWR net66 sky130_fd_sc_hd__dfxtp_1
XFILLER_35_165 VGND VGND VPWR VPWR sky130_fd_sc_hd__decap_3
Xrebuffer73 _0407_ VGND VGND VPWR VPWR net209 sky130_fd_sc_hd__dlygate4sd1_1
Xrebuffer62 net199 VGND VGND VPWR VPWR net198 sky130_fd_sc_hd__dlymetal6s2s_1
Xrebuffer51 net185 VGND VGND VPWR VPWR net187 sky130_fd_sc_hd__dlymetal6s2s_1
Xrebuffer40 net177 VGND VGND VPWR VPWR net176 sky130_fd_sc_hd__buf_1
Xrebuffer84 net219 VGND VGND VPWR VPWR net220 sky130_fd_sc_hd__dlygate4sd1_1
Xrebuffer152 net304 VGND VGND VPWR VPWR net288 sky130_fd_sc_hd__dlymetal6s2s_1
XFILLER_1_242 VGND VGND VPWR VPWR sky130_fd_sc_hd__decap_6
X_0882_ _0226_ net58 net60 VGND VGND VPWR VPWR _0230_ sky130_fd_sc_hd__and3_1
X_0951_ _0256_ _0257_ _0282_ _0242_ VGND VGND VPWR VPWR _0284_ sky130_fd_sc_hd__nand4_4
X_1434_ clknet_3_5__leaf_clk _0060_ VGND VGND VPWR VPWR net30 sky130_fd_sc_hd__dfxtp_1
X_1296_ _0616_ _0618_ _0620_ VGND VGND VPWR VPWR _0622_ sky130_fd_sc_hd__nand3b_1
X_1365_ _0683_ _0678_ _0685_ _0686_ VGND VGND VPWR VPWR _0058_ sky130_fd_sc_hd__a31oi_1
XTAP_TAPCELL_ROW_18_171 VGND VPWR sky130_fd_sc_hd__tapvpwrvgnd_1
XFILLER_36_21 VGND VGND VPWR VPWR sky130_fd_sc_hd__decap_6
Xinput18 reset VGND VGND VPWR VPWR net18 sky130_fd_sc_hd__clkbuf_2
X_1150_ _0467_ _0471_ _0405_ _0423_ _0474_ VGND VGND VPWR VPWR _0479_ sky130_fd_sc_hd__o221ai_4
XFILLER_37_249 VGND VGND VPWR VPWR sky130_fd_sc_hd__fill_1
X_1081_ net105 net126 net103 net123 VGND VGND VPWR VPWR _0411_ sky130_fd_sc_hd__and4_1
X_0865_ _0215_ _0217_ net82 VGND VGND VPWR VPWR _0026_ sky130_fd_sc_hd__and3_1
X_0934_ net107 net89 net132 net103 VGND VGND VPWR VPWR _0267_ sky130_fd_sc_hd__nand4_2
X_1417_ clknet_3_4__leaf_clk _0043_ VGND VGND VPWR VPWR product_reg\[0\] sky130_fd_sc_hd__dfxtp_4
X_0796_ _0161_ _0070_ _0160_ _0162_ net82 VGND VGND VPWR VPWR _0012_ sky130_fd_sc_hd__o311a_1
X_1279_ _0576_ _0579_ VGND VGND VPWR VPWR _0605_ sky130_fd_sc_hd__nand2_1
XFILLER_28_205 VGND VGND VPWR VPWR sky130_fd_sc_hd__fill_2
X_1348_ _0669_ _0670_ net78 _0671_ VGND VGND VPWR VPWR _0056_ sky130_fd_sc_hd__a31oi_1
XTAP_TAPCELL_ROW_21_188 VGND VPWR sky130_fd_sc_hd__tapvpwrvgnd_1
XFILLER_22_67 VGND VGND VPWR VPWR sky130_fd_sc_hd__decap_8
XFILLER_22_89 VGND VGND VPWR VPWR sky130_fd_sc_hd__fill_1
XTAP_TAPCELL_ROW_6_120 VGND VPWR sky130_fd_sc_hd__tapvpwrvgnd_1
XFILLER_19_205 VGND VGND VPWR VPWR sky130_fd_sc_hd__fill_1
XTAP_TAPCELL_ROW_29_222 VGND VPWR sky130_fd_sc_hd__tapvpwrvgnd_1
XTAP_TAPCELL_ROW_12_144 VGND VPWR sky130_fd_sc_hd__tapvpwrvgnd_1
X_1202_ _0076_ _0078_ _0526_ _0529_ VGND VGND VPWR VPWR _0530_ sky130_fd_sc_hd__o211ai_2
X_1064_ net154 _0326_ _0331_ VGND VGND VPWR VPWR _0394_ sky130_fd_sc_hd__o21a_4
X_1133_ net134 net130 net214 net93 VGND VGND VPWR VPWR _0462_ sky130_fd_sc_hd__and4_1
X_0848_ net297 _0204_ net333 VGND VGND VPWR VPWR _0206_ sky130_fd_sc_hd__a21oi_2
X_0917_ _0249_ net111 net11 _0247_ VGND VGND VPWR VPWR _0251_ sky130_fd_sc_hd__nand4_2
X_0779_ _0145_ _0146_ _0147_ VGND VGND VPWR VPWR _0148_ sky130_fd_sc_hd__a21oi_1
XFILLER_17_34 VGND VGND VPWR VPWR sky130_fd_sc_hd__decap_8
XFILLER_3_167 VGND VGND VPWR VPWR sky130_fd_sc_hd__fill_1
XTAP_TAPCELL_ROW_40_272 VGND VPWR sky130_fd_sc_hd__tapvpwrvgnd_1
X_0702_ net17 net18 VGND VGND VPWR VPWR _0082_ sky130_fd_sc_hd__nor2_1
X_1116_ _0440_ _0375_ VGND VGND VPWR VPWR _0446_ sky130_fd_sc_hd__nand2_2
X_1047_ _0374_ _0376_ _0320_ VGND VGND VPWR VPWR _0378_ sky130_fd_sc_hd__a21o_1
XFILLER_12_222 VGND VGND VPWR VPWR sky130_fd_sc_hd__decap_4
XFILLER_12_233 VGND VGND VPWR VPWR sky130_fd_sc_hd__decap_3
XPHY_EDGE_ROW_13_Right_13 VGND VGND VPWR VPWR sky130_fd_sc_hd__decap_3
XPHY_EDGE_ROW_22_Right_22 VGND VGND VPWR VPWR sky130_fd_sc_hd__decap_3
Xhold204 net55 VGND VGND VPWR VPWR net340 sky130_fd_sc_hd__dlygate4sd3_1
XPHY_EDGE_ROW_31_Right_31 VGND VGND VPWR VPWR sky130_fd_sc_hd__decap_3
XPHY_EDGE_ROW_40_Right_40 VGND VGND VPWR VPWR sky130_fd_sc_hd__decap_3
XFILLER_39_65 VGND VGND VPWR VPWR sky130_fd_sc_hd__fill_2
XFILLER_29_185 VGND VGND VPWR VPWR sky130_fd_sc_hd__decap_6
XFILLER_4_251 VGND VGND VPWR VPWR sky130_fd_sc_hd__fill_1
X_1381_ clknet_3_7__leaf_clk _0007_ VGND VGND VPWR VPWR net65 sky130_fd_sc_hd__dfxtp_1
Xrebuffer52 _0393_ VGND VGND VPWR VPWR net188 sky130_fd_sc_hd__buf_2
Xrebuffer30 net165 VGND VGND VPWR VPWR net166 sky130_fd_sc_hd__dlygate4sd1_1
Xrebuffer41 net181 VGND VGND VPWR VPWR net177 sky130_fd_sc_hd__buf_1
Xrebuffer74 _0498_ VGND VGND VPWR VPWR net210 sky130_fd_sc_hd__buf_6
Xrebuffer85 net220 VGND VGND VPWR VPWR net221 sky130_fd_sc_hd__dlygate4sd1_1
Xrebuffer153 net288 VGND VGND VPWR VPWR net289 sky130_fd_sc_hd__dlymetal6s4s_1
X_0881_ net58 net57 _0224_ net60 VGND VGND VPWR VPWR _0229_ sky130_fd_sc_hd__a31o_1
X_0950_ _0281_ _0282_ VGND VGND VPWR VPWR _0283_ sky130_fd_sc_hd__nand2_1
X_1433_ clknet_3_5__leaf_clk _0059_ VGND VGND VPWR VPWR net29 sky130_fd_sc_hd__dfxtp_1
X_1295_ _0616_ _0617_ _0620_ VGND VGND VPWR VPWR _0621_ sky130_fd_sc_hd__o21bai_1
X_1364_ product_reg\[15\] net78 net81 VGND VGND VPWR VPWR _0686_ sky130_fd_sc_hd__o21ai_1
XTAP_TAPCELL_ROW_18_172 VGND VPWR sky130_fd_sc_hd__tapvpwrvgnd_1
Xinput19 v_a_in VGND VGND VPWR VPWR net19 sky130_fd_sc_hd__clkbuf_2
X_1080_ net125 net102 net122 net105 VGND VGND VPWR VPWR _0410_ sky130_fd_sc_hd__a22o_4
X_0864_ v_pipe _0196_ net74 _0216_ VGND VGND VPWR VPWR _0217_ sky130_fd_sc_hd__nand4_1
X_0795_ v_pipe net39 VGND VGND VPWR VPWR _0162_ sky130_fd_sc_hd__or2_1
X_0933_ net107 net132 net103 net89 VGND VGND VPWR VPWR _0266_ sky130_fd_sc_hd__a22o_2
X_1416_ clknet_3_0__leaf_clk _0042_ VGND VGND VPWR VPWR net28 sky130_fd_sc_hd__dfxtp_1
X_1347_ net313 net78 net81 VGND VGND VPWR VPWR _0671_ sky130_fd_sc_hd__o21ai_1
XFILLER_36_250 VGND VGND VPWR VPWR sky130_fd_sc_hd__fill_2
X_1278_ _0602_ _0604_ net330 _0232_ VGND VGND VPWR VPWR _0053_ sky130_fd_sc_hd__a2bb2o_4
XFILLER_22_13 VGND VGND VPWR VPWR sky130_fd_sc_hd__fill_1
XTAP_TAPCELL_ROW_6_121 VGND VPWR sky130_fd_sc_hd__tapvpwrvgnd_1
Xfanout130 net11 VGND VGND VPWR VPWR net130 sky130_fd_sc_hd__buf_8
XTAP_TAPCELL_ROW_29_223 VGND VPWR sky130_fd_sc_hd__tapvpwrvgnd_1
XFILLER_42_253 VGND VGND VPWR VPWR sky130_fd_sc_hd__fill_1
XTAP_TAPCELL_ROW_12_145 VGND VPWR sky130_fd_sc_hd__tapvpwrvgnd_1
X_1201_ net125 net121 net95 net99 VGND VGND VPWR VPWR _0529_ sky130_fd_sc_hd__nand4_4
X_1063_ net154 _0326_ _0331_ VGND VGND VPWR VPWR _0393_ sky130_fd_sc_hd__o21ai_4
X_1132_ net167 net93 VGND VGND VPWR VPWR _0461_ sky130_fd_sc_hd__nand2_2
X_0916_ net129 net111 _0247_ _0249_ VGND VGND VPWR VPWR _0250_ sky130_fd_sc_hd__a22o_1
XTAP_TAPCELL_ROW_35_248 VGND VPWR sky130_fd_sc_hd__tapvpwrvgnd_1
X_0847_ _0203_ _0205_ net83 VGND VGND VPWR VPWR _0020_ sky130_fd_sc_hd__and3_1
X_0778_ _0138_ _0144_ VGND VGND VPWR VPWR _0147_ sky130_fd_sc_hd__and2_1
XFILLER_16_209 VGND VGND VPWR VPWR sky130_fd_sc_hd__decap_6
XFILLER_17_57 VPWR VGND VPWR VGND sky130_ef_sc_hd__decap_12
XFILLER_24_253 VGND VGND VPWR VPWR sky130_fd_sc_hd__fill_1
XTAP_TAPCELL_ROW_40_273 VGND VPWR sky130_fd_sc_hd__tapvpwrvgnd_1
X_0701_ net114 VGND VGND VPWR VPWR _0081_ sky130_fd_sc_hd__inv_2
XFILLER_31_3 VPWR VGND VPWR VGND sky130_ef_sc_hd__decap_12
X_1115_ _0440_ _0443_ _0375_ VGND VGND VPWR VPWR _0445_ sky130_fd_sc_hd__a21oi_4
X_1046_ _0374_ _0376_ VGND VGND VPWR VPWR _0377_ sky130_fd_sc_hd__nand2_2
XFILLER_0_138 VGND VGND VPWR VPWR sky130_fd_sc_hd__fill_2
XFILLER_28_45 VGND VGND VPWR VPWR sky130_fd_sc_hd__fill_2
XFILLER_12_201 VGND VGND VPWR VPWR sky130_fd_sc_hd__fill_1
XFILLER_38_153 VGND VGND VPWR VPWR sky130_fd_sc_hd__decap_3
X_1029_ _0353_ _0355_ _0357_ VGND VGND VPWR VPWR _0360_ sky130_fd_sc_hd__and3_1
XFILLER_5_208 VPWR VGND VPWR VGND sky130_ef_sc_hd__decap_12
X_1380_ clknet_3_7__leaf_clk _0006_ VGND VGND VPWR VPWR net64 sky130_fd_sc_hd__dfxtp_1
XFILLER_6_92 VGND VGND VPWR VPWR sky130_fd_sc_hd__fill_1
Xrebuffer42 _0406_ VGND VGND VPWR VPWR net178 sky130_fd_sc_hd__buf_6
Xrebuffer20 _0407_ VGND VGND VPWR VPWR net156 sky130_fd_sc_hd__buf_6
Xrebuffer31 net130 VGND VGND VPWR VPWR net167 sky130_fd_sc_hd__dlymetal6s4s_1
Xrebuffer86 net221 VGND VGND VPWR VPWR net222 sky130_fd_sc_hd__dlymetal6s2s_1
Xrebuffer64 _0557_ VGND VGND VPWR VPWR net200 sky130_fd_sc_hd__dlymetal6s2s_1
Xrebuffer53 _0653_ VGND VGND VPWR VPWR net189 sky130_fd_sc_hd__buf_2
Xrebuffer75 _0511_ VGND VGND VPWR VPWR net211 sky130_fd_sc_hd__clkbuf_1
XFILLER_25_46 VGND VGND VPWR VPWR sky130_fd_sc_hd__decap_4
Xrebuffer154 _0182_ VGND VGND VPWR VPWR net290 sky130_fd_sc_hd__clkbuf_2
X_0880_ net58 _0226_ net81 _0228_ VGND VGND VPWR VPWR _0030_ sky130_fd_sc_hd__o211a_1
X_1363_ _0080_ net87 _0633_ net19 net20 VGND VGND VPWR VPWR _0685_ sky130_fd_sc_hd__o311a_1
X_1432_ clknet_3_0__leaf_clk _0058_ VGND VGND VPWR VPWR product_reg\[15\] sky130_fd_sc_hd__dfxtp_1
X_1294_ net102 net116 _0526_ _0571_ _0619_ VGND VGND VPWR VPWR _0620_ sky130_fd_sc_hd__a41o_1
XTAP_TAPCELL_ROW_18_173 VGND VPWR sky130_fd_sc_hd__tapvpwrvgnd_1
XFILLER_31_181 VPWR VGND VPWR VGND sky130_ef_sc_hd__decap_12
XFILLER_11_37 VGND VGND VPWR VPWR sky130_fd_sc_hd__fill_1
XTAP_TAPCELL_ROW_24_198 VGND VPWR sky130_fd_sc_hd__tapvpwrvgnd_1
XFILLER_37_207 VGND VGND VPWR VPWR sky130_fd_sc_hd__fill_1
XFILLER_9_141 VGND VGND VPWR VPWR sky130_fd_sc_hd__fill_1
X_0932_ net106 net132 net103 net89 VGND VGND VPWR VPWR _0265_ sky130_fd_sc_hd__a22oi_4
X_0863_ net54 net53 net52 VGND VGND VPWR VPWR _0216_ sky130_fd_sc_hd__and3_1
X_0794_ _0151_ _0155_ _0157_ _0158_ VGND VGND VPWR VPWR _0161_ sky130_fd_sc_hd__a22oi_1
X_1415_ clknet_3_0__leaf_clk _0041_ VGND VGND VPWR VPWR net27 sky130_fd_sc_hd__dfxtp_1
X_1346_ _0649_ _0655_ _0668_ VGND VGND VPWR VPWR _0670_ sky130_fd_sc_hd__nand3_1
X_1277_ _0569_ _0567_ _0601_ _0086_ VGND VGND VPWR VPWR _0604_ sky130_fd_sc_hd__a31o_1
XFILLER_22_25 VGND VGND VPWR VPWR sky130_fd_sc_hd__decap_3
Xfanout131 net133 VGND VGND VPWR VPWR net131 sky130_fd_sc_hd__buf_8
XPHY_EDGE_ROW_5_Left_48 VGND VGND VPWR VPWR sky130_fd_sc_hd__decap_3
Xfanout120 net14 VGND VGND VPWR VPWR net120 sky130_fd_sc_hd__clkbuf_2
XTAP_TAPCELL_ROW_29_224 VGND VPWR sky130_fd_sc_hd__tapvpwrvgnd_1
XFILLER_6_188 VGND VGND VPWR VPWR sky130_fd_sc_hd__fill_1
XFILLER_10_195 VGND VGND VPWR VPWR sky130_fd_sc_hd__fill_1
XTAP_TAPCELL_ROW_12_146 VGND VPWR sky130_fd_sc_hd__tapvpwrvgnd_1
X_1200_ net125 net121 net95 net99 VGND VGND VPWR VPWR _0528_ sky130_fd_sc_hd__and4_1
X_1131_ net165 net96 net93 net134 VGND VGND VPWR VPWR _0460_ sky130_fd_sc_hd__a22o_2
X_1062_ _0388_ _0389_ VGND VGND VPWR VPWR _0392_ sky130_fd_sc_hd__nor2_2
XTAP_TAPCELL_ROW_35_249 VGND VPWR sky130_fd_sc_hd__tapvpwrvgnd_1
X_0915_ net106 net219 net133 net109 VGND VGND VPWR VPWR _0249_ sky130_fd_sc_hd__a22o_1
X_0846_ net298 _0204_ VGND VGND VPWR VPWR _0205_ sky130_fd_sc_hd__nand2_1
X_0777_ product_reg\[9\] net68 VGND VGND VPWR VPWR _0146_ sky130_fd_sc_hd__or2_1
X_1329_ _0598_ _0624_ _0625_ VGND VGND VPWR VPWR _0654_ sky130_fd_sc_hd__o21ai_2
XFILLER_15_232 VPWR VGND VPWR VGND sky130_ef_sc_hd__decap_12
XTAP_TAPCELL_ROW_40_274 VGND VPWR sky130_fd_sc_hd__tapvpwrvgnd_1
X_0700_ net203 VGND VGND VPWR VPWR _0080_ sky130_fd_sc_hd__inv_2
X_1114_ _0436_ _0441_ _0440_ VGND VGND VPWR VPWR _0444_ sky130_fd_sc_hd__o21a_1
X_1045_ _0360_ _0373_ _0372_ _0323_ VGND VGND VPWR VPWR _0376_ sky130_fd_sc_hd__o211ai_4
XTAP_TAPCELL_ROW_31_230 VGND VPWR sky130_fd_sc_hd__tapvpwrvgnd_1
X_0829_ _0189_ _0190_ _0191_ net81 VGND VGND VPWR VPWR _0016_ sky130_fd_sc_hd__o211a_1
XFILLER_8_217 VGND VGND VPWR VPWR sky130_fd_sc_hd__fill_1
XPHY_EDGE_ROW_8_Left_51 VGND VGND VPWR VPWR sky130_fd_sc_hd__decap_3
XPHY_EDGE_ROW_7_Right_7 VGND VGND VPWR VPWR sky130_fd_sc_hd__decap_3
X_1028_ _0351_ _0356_ _0352_ VGND VGND VPWR VPWR _0359_ sky130_fd_sc_hd__nand3_4
XFILLER_39_23 VGND VGND VPWR VPWR sky130_fd_sc_hd__decap_3
XFILLER_29_143 VGND VGND VPWR VPWR sky130_fd_sc_hd__fill_1
XPHY_EDGE_ROW_34_Left_77 VGND VGND VPWR VPWR sky130_fd_sc_hd__decap_3
XFILLER_4_253 VGND VGND VPWR VPWR sky130_fd_sc_hd__fill_1
Xrebuffer54 _0406_ VGND VGND VPWR VPWR net190 sky130_fd_sc_hd__buf_6
Xrebuffer76 _0403_ VGND VGND VPWR VPWR net212 sky130_fd_sc_hd__dlymetal6s2s_1
Xrebuffer65 _0398_ VGND VGND VPWR VPWR net201 sky130_fd_sc_hd__buf_6
Xrebuffer32 net130 VGND VGND VPWR VPWR net168 sky130_fd_sc_hd__dlygate4sd1_1
Xrebuffer10 _0381_ VGND VGND VPWR VPWR net146 sky130_fd_sc_hd__dlygate4sd1_1
Xrebuffer87 net219 VGND VGND VPWR VPWR net223 sky130_fd_sc_hd__dlygate4sd1_1
XFILLER_25_14 VGND VGND VPWR VPWR sky130_fd_sc_hd__decap_6
Xrebuffer21 _0509_ VGND VGND VPWR VPWR net157 sky130_fd_sc_hd__clkbuf_2
Xrebuffer43 net211 VGND VGND VPWR VPWR net179 sky130_fd_sc_hd__buf_6
XFILLER_41_57 VGND VGND VPWR VPWR sky130_fd_sc_hd__fill_1
Xrebuffer155 _0126_ VGND VGND VPWR VPWR net291 sky130_fd_sc_hd__dlygate4sd1_1
Xrebuffer166 _0182_ VGND VGND VPWR VPWR net302 sky130_fd_sc_hd__buf_6
XFILLER_1_223 VGND VGND VPWR VPWR sky130_fd_sc_hd__fill_1
X_1293_ _0572_ net114 net105 VGND VGND VPWR VPWR _0619_ sky130_fd_sc_hd__and3_1
X_1362_ _0067_ net17 net18 net78 _0684_ VGND VGND VPWR VPWR _0057_ sky130_fd_sc_hd__o41ai_2
X_1431_ clknet_3_3__leaf_clk _0057_ VGND VGND VPWR VPWR product_reg\[14\] sky130_fd_sc_hd__dfxtp_1
XTAP_TAPCELL_ROW_18_174 VGND VPWR sky130_fd_sc_hd__tapvpwrvgnd_1
XFILLER_31_193 VPWR VGND VPWR VGND sky130_ef_sc_hd__decap_12
XTAP_TAPCELL_ROW_24_199 VGND VPWR sky130_fd_sc_hd__tapvpwrvgnd_1
XTAP_TAPCELL_ROW_9_131 VGND VPWR sky130_fd_sc_hd__tapvpwrvgnd_1
XPHY_EDGE_ROW_37_Left_80 VGND VGND VPWR VPWR sky130_fd_sc_hd__decap_3
X_0862_ net53 net52 net298 _0210_ net334 VGND VGND VPWR VPWR _0215_ sky130_fd_sc_hd__a41o_1
X_0931_ net109 net129 VGND VGND VPWR VPWR _0264_ sky130_fd_sc_hd__nand2_1
XFILLER_13_193 VGND VGND VPWR VPWR sky130_fd_sc_hd__decap_4
XPHY_EDGE_ROW_21_Left_64 VGND VGND VPWR VPWR sky130_fd_sc_hd__decap_3
Xrebuffer1 _0339_ VGND VGND VPWR VPWR net137 sky130_fd_sc_hd__dlymetal6s2s_1
X_0793_ _0151_ _0155_ _0157_ _0158_ VGND VGND VPWR VPWR _0160_ sky130_fd_sc_hd__and4_1
XFILLER_3_83 VGND VGND VPWR VPWR sky130_fd_sc_hd__fill_1
X_1414_ clknet_3_0__leaf_clk _0040_ VGND VGND VPWR VPWR net26 sky130_fd_sc_hd__dfxtp_1
X_1345_ _0649_ _0655_ _0665_ _0667_ VGND VGND VPWR VPWR _0669_ sky130_fd_sc_hd__o2bb2ai_1
X_1276_ _0569_ _0567_ _0601_ VGND VGND VPWR VPWR _0603_ sky130_fd_sc_hd__a21o_1
Xfanout110 net3 VGND VGND VPWR VPWR net110 sky130_fd_sc_hd__clkbuf_4
Xfanout132 net133 VGND VGND VPWR VPWR net132 sky130_fd_sc_hd__clkbuf_2
Xfanout121 net122 VGND VGND VPWR VPWR net121 sky130_fd_sc_hd__buf_6
XTAP_TAPCELL_ROW_12_147 VGND VPWR sky130_fd_sc_hd__tapvpwrvgnd_1
XTAP_TAPCELL_ROW_20_180 VGND VPWR sky130_fd_sc_hd__tapvpwrvgnd_1
X_1130_ net167 net214 net93 net134 VGND VGND VPWR VPWR _0459_ sky130_fd_sc_hd__a22oi_2
X_1061_ _0384_ _0387_ net136 net115 VGND VGND VPWR VPWR _0391_ sky130_fd_sc_hd__o211a_1
X_0845_ net47 net46 net45 net44 VGND VGND VPWR VPWR _0204_ sky130_fd_sc_hd__and4_1
X_0914_ net106 net89 net132 net109 VGND VGND VPWR VPWR _0248_ sky130_fd_sc_hd__a22oi_1
X_0776_ product_reg\[9\] net68 VGND VGND VPWR VPWR _0145_ sky130_fd_sc_hd__nand2_1
X_1259_ _0463_ _0535_ _0580_ _0581_ VGND VGND VPWR VPWR _0586_ sky130_fd_sc_hd__o2bb2ai_4
XTAP_TAPCELL_ROW_3_104 VGND VPWR sky130_fd_sc_hd__tapvpwrvgnd_1
X_1328_ _0566_ _0515_ _0652_ VGND VGND VPWR VPWR _0653_ sky130_fd_sc_hd__o21ai_4
XFILLER_15_244 VGND VGND VPWR VPWR sky130_fd_sc_hd__fill_2
X_1044_ _0360_ _0373_ _0372_ _0323_ VGND VGND VPWR VPWR _0375_ sky130_fd_sc_hd__o211a_2
XFILLER_17_3 VGND VGND VPWR VPWR sky130_fd_sc_hd__fill_1
X_1113_ _0366_ _0437_ net226 VGND VGND VPWR VPWR _0443_ sky130_fd_sc_hd__nand3b_4
XFILLER_21_203 VGND VGND VPWR VPWR sky130_fd_sc_hd__decap_4
XTAP_TAPCELL_ROW_31_231 VGND VPWR sky130_fd_sc_hd__tapvpwrvgnd_1
X_0759_ net77 net328 net84 _0130_ VGND VGND VPWR VPWR _0007_ sky130_fd_sc_hd__o211a_1
X_0828_ net75 net43 VGND VGND VPWR VPWR _0191_ sky130_fd_sc_hd__or2_1
XFILLER_7_251 VGND VGND VPWR VPWR sky130_fd_sc_hd__decap_3
XFILLER_38_144 VGND VGND VPWR VPWR sky130_fd_sc_hd__decap_6
X_1027_ _0353_ _0355_ _0357_ VGND VGND VPWR VPWR _0358_ sky130_fd_sc_hd__a21oi_1
Xclkbuf_3_5__f_clk clknet_0_clk VGND VGND VPWR VPWR clknet_3_5__leaf_clk sky130_fd_sc_hd__clkbuf_16
XFILLER_14_27 VGND VGND VPWR VPWR sky130_fd_sc_hd__fill_1
XFILLER_30_15 VPWR VGND VPWR VGND sky130_ef_sc_hd__decap_12
XFILLER_4_221 VGND VGND VPWR VPWR sky130_fd_sc_hd__fill_1
XFILLER_35_125 VGND VGND VPWR VPWR sky130_fd_sc_hd__fill_1
Xrebuffer11 net101 VGND VGND VPWR VPWR net147 sky130_fd_sc_hd__buf_6
XFILLER_41_117 VGND VGND VPWR VPWR sky130_fd_sc_hd__fill_1
Xrebuffer44 net202 VGND VGND VPWR VPWR net180 sky130_fd_sc_hd__dlygate4sd1_1
Xrebuffer66 _0398_ VGND VGND VPWR VPWR net202 sky130_fd_sc_hd__buf_1
Xrebuffer88 _0396_ VGND VGND VPWR VPWR net224 sky130_fd_sc_hd__buf_6
Xrebuffer77 _0403_ VGND VGND VPWR VPWR net213 sky130_fd_sc_hd__buf_2
Xrebuffer55 _0396_ VGND VGND VPWR VPWR net191 sky130_fd_sc_hd__dlygate4sd1_1
Xrebuffer22 _0430_ VGND VGND VPWR VPWR net158 sky130_fd_sc_hd__dlymetal6s2s_1
Xrebuffer33 _0504_ VGND VGND VPWR VPWR net169 sky130_fd_sc_hd__buf_6
Xrebuffer156 net293 VGND VGND VPWR VPWR net292 sky130_fd_sc_hd__dlygate4sd1_1
Xrebuffer167 product_reg\[1\] VGND VGND VPWR VPWR net303 sky130_fd_sc_hd__dlygate4sd1_1
X_1430_ clknet_3_1__leaf_clk _0056_ VGND VGND VPWR VPWR product_reg\[13\] sky130_fd_sc_hd__dfxtp_1
X_1292_ _0613_ _0615_ _0586_ _0588_ VGND VGND VPWR VPWR _0618_ sky130_fd_sc_hd__o211ai_2
X_1361_ _0681_ _0676_ _0000_ _0682_ VGND VGND VPWR VPWR _0684_ sky130_fd_sc_hd__o211ai_2
XTAP_TAPCELL_ROW_18_175 VGND VPWR sky130_fd_sc_hd__tapvpwrvgnd_1
XTAP_TAPCELL_ROW_9_132 VGND VPWR sky130_fd_sc_hd__tapvpwrvgnd_1
X_0861_ _0214_ _0213_ net82 VGND VGND VPWR VPWR _0025_ sky130_fd_sc_hd__and3_1
Xrebuffer2 _0339_ VGND VGND VPWR VPWR net138 sky130_fd_sc_hd__buf_6
X_0930_ _0246_ _0248_ _0247_ VGND VGND VPWR VPWR _0263_ sky130_fd_sc_hd__o21a_1
XFILLER_13_150 VPWR VGND VPWR VGND sky130_ef_sc_hd__decap_12
X_0792_ _0155_ _0151_ _0158_ VGND VGND VPWR VPWR _0159_ sky130_fd_sc_hd__nand3_4
X_1413_ clknet_3_1__leaf_clk _0039_ VGND VGND VPWR VPWR net25 sky130_fd_sc_hd__dfxtp_1
XFILLER_36_253 VGND VGND VPWR VPWR sky130_fd_sc_hd__fill_1
X_1344_ _0665_ _0667_ VGND VGND VPWR VPWR _0668_ sky130_fd_sc_hd__nor2_1
X_1275_ _0569_ _0567_ _0601_ VGND VGND VPWR VPWR _0602_ sky130_fd_sc_hd__a21oi_4
Xfanout111 net2 VGND VGND VPWR VPWR net111 sky130_fd_sc_hd__clkbuf_4
Xfanout133 net10 VGND VGND VPWR VPWR net133 sky130_fd_sc_hd__buf_6
Xfanout122 net124 VGND VGND VPWR VPWR net122 sky130_fd_sc_hd__buf_6
Xfanout100 net101 VGND VGND VPWR VPWR net100 sky130_fd_sc_hd__buf_6
XFILLER_27_253 VGND VGND VPWR VPWR sky130_fd_sc_hd__fill_1
XPHY_EDGE_ROW_29_Right_29 VGND VGND VPWR VPWR sky130_fd_sc_hd__decap_3
XPHY_EDGE_ROW_38_Right_38 VGND VGND VPWR VPWR sky130_fd_sc_hd__decap_3
XFILLER_10_131 VGND VGND VPWR VPWR sky130_fd_sc_hd__fill_1
XTAP_TAPCELL_ROW_12_148 VGND VPWR sky130_fd_sc_hd__tapvpwrvgnd_1
XTAP_TAPCELL_ROW_20_181 VGND VPWR sky130_fd_sc_hd__tapvpwrvgnd_1
X_1060_ _0075_ net87 _0385_ _0386_ VGND VGND VPWR VPWR _0390_ sky130_fd_sc_hd__o211a_1
XFILLER_37_90 VGND VGND VPWR VPWR sky130_fd_sc_hd__fill_1
XFILLER_18_253 VGND VGND VPWR VPWR sky130_fd_sc_hd__fill_1
X_0844_ net71 net45 net44 net46 net332 VGND VGND VPWR VPWR _0203_ sky130_fd_sc_hd__a41o_1
X_0913_ net106 net195 net131 net109 VGND VGND VPWR VPWR _0247_ sky130_fd_sc_hd__nand4_2
X_0775_ net77 net329 _0142_ _0143_ net83 VGND VGND VPWR VPWR _0009_ sky130_fd_sc_hd__o221a_1
XTAP_TAPCELL_ROW_3_105 VGND VPWR sky130_fd_sc_hd__tapvpwrvgnd_1
X_1258_ _0329_ _0461_ _0535_ _0584_ VGND VGND VPWR VPWR _0585_ sky130_fd_sc_hd__o211ai_4
X_1327_ _0568_ _0559_ _0651_ VGND VGND VPWR VPWR _0652_ sky130_fd_sc_hd__a21oi_4
XTAP_TAPCELL_ROW_26_207 VGND VPWR sky130_fd_sc_hd__tapvpwrvgnd_1
X_1189_ net309 _0232_ _0517_ _0516_ VGND VGND VPWR VPWR _0051_ sky130_fd_sc_hd__a22o_1
X_1043_ _0315_ _0318_ _0370_ _0371_ VGND VGND VPWR VPWR _0374_ sky130_fd_sc_hd__nand4_2
X_1112_ _0362_ net227 _0437_ _0364_ VGND VGND VPWR VPWR _0442_ sky130_fd_sc_hd__and4b_1
XFILLER_21_248 VGND VGND VPWR VPWR sky130_fd_sc_hd__fill_2
XTAP_TAPCELL_ROW_31_232 VGND VPWR sky130_fd_sc_hd__tapvpwrvgnd_1
X_0827_ _0185_ _0180_ _0187_ _0188_ _0070_ VGND VGND VPWR VPWR _0190_ sky130_fd_sc_hd__a41o_1
X_0758_ _0127_ _0128_ net76 VGND VGND VPWR VPWR _0130_ sky130_fd_sc_hd__o21ai_1
X_0689_ product_reg\[5\] VGND VGND VPWR VPWR _0069_ sky130_fd_sc_hd__inv_2
XFILLER_38_189 VGND VGND VPWR VPWR sky130_fd_sc_hd__fill_1
X_1026_ _0295_ _0307_ _0309_ VGND VGND VPWR VPWR _0357_ sky130_fd_sc_hd__o21ai_4
XFILLER_30_27 VGND VGND VPWR VPWR sky130_fd_sc_hd__fill_1
Xrebuffer45 net182 VGND VGND VPWR VPWR net181 sky130_fd_sc_hd__buf_1
Xrebuffer12 net147 VGND VGND VPWR VPWR net148 sky130_fd_sc_hd__buf_6
Xrebuffer23 _0430_ VGND VGND VPWR VPWR net159 sky130_fd_sc_hd__buf_6
Xrebuffer34 _0430_ VGND VGND VPWR VPWR net170 sky130_fd_sc_hd__buf_1
X_1009_ net113 net120 VGND VGND VPWR VPWR _0340_ sky130_fd_sc_hd__nand2_1
Xrebuffer56 net224 VGND VGND VPWR VPWR net192 sky130_fd_sc_hd__buf_6
Xrebuffer67 net92 VGND VGND VPWR VPWR net203 sky130_fd_sc_hd__dlygate4sd1_1
Xrebuffer78 net96 VGND VGND VPWR VPWR net214 sky130_fd_sc_hd__buf_2
Xrebuffer89 _0427_ VGND VGND VPWR VPWR net225 sky130_fd_sc_hd__clkbuf_2
XFILLER_34_181 VGND VGND VPWR VPWR sky130_fd_sc_hd__fill_1
Xrebuffer157 net294 VGND VGND VPWR VPWR net293 sky130_fd_sc_hd__dlygate4sd1_1
Xrebuffer168 net305 VGND VGND VPWR VPWR net304 sky130_fd_sc_hd__dlygate4sd1_1
Xrebuffer146 _0103_ VGND VGND VPWR VPWR net282 sky130_fd_sc_hd__dlygate4sd1_1
X_1360_ _0674_ _0673_ _0680_ _0679_ VGND VGND VPWR VPWR _0683_ sky130_fd_sc_hd__o2bb2ai_2
Xoutput70 net70 VGND VGND VPWR VPWR v_b_out sky130_fd_sc_hd__buf_2
X_1291_ _0613_ _0615_ _0586_ _0588_ VGND VGND VPWR VPWR _0617_ sky130_fd_sc_hd__o211a_1
XFILLER_36_15 VGND VGND VPWR VPWR sky130_fd_sc_hd__fill_1
XFILLER_22_195 VGND VGND VPWR VPWR sky130_fd_sc_hd__fill_1
XTAP_TAPCELL_ROW_9_133 VGND VPWR sky130_fd_sc_hd__tapvpwrvgnd_1
XFILLER_26_70 VGND VGND VPWR VPWR sky130_fd_sc_hd__fill_1
X_0860_ net72 net52 net53 _0210_ VGND VGND VPWR VPWR _0214_ sky130_fd_sc_hd__nand4_4
XFILLER_13_162 VGND VGND VPWR VPWR sky130_fd_sc_hd__fill_1
Xrebuffer3 _0437_ VGND VGND VPWR VPWR net139 sky130_fd_sc_hd__dlymetal6s2s_1
X_0791_ product_reg\[11\] net39 VGND VGND VPWR VPWR _0158_ sky130_fd_sc_hd__nand2_1
XFILLER_3_41 VGND VGND VPWR VPWR sky130_fd_sc_hd__fill_1
X_1412_ clknet_3_5__leaf_clk _0038_ VGND VGND VPWR VPWR net24 sky130_fd_sc_hd__dfxtp_1
X_1343_ _0666_ VGND VGND VPWR VPWR _0667_ sky130_fd_sc_hd__inv_2
XFILLER_36_210 VGND VGND VPWR VPWR sky130_fd_sc_hd__fill_2
X_1274_ _0598_ _0599_ VGND VGND VPWR VPWR _0601_ sky130_fd_sc_hd__or2_1
XFILLER_22_17 VGND VGND VPWR VPWR sky130_fd_sc_hd__decap_8
X_0989_ _0281_ _0284_ _0319_ VGND VGND VPWR VPWR _0321_ sky130_fd_sc_hd__a21o_1
Xfanout134 net10 VGND VGND VPWR VPWR net134 sky130_fd_sc_hd__buf_4
Xfanout101 net6 VGND VGND VPWR VPWR net101 sky130_fd_sc_hd__buf_8
Xfanout123 net124 VGND VGND VPWR VPWR net123 sky130_fd_sc_hd__buf_4
Xfanout112 net2 VGND VGND VPWR VPWR net112 sky130_fd_sc_hd__clkbuf_2
XTAP_TAPCELL_ROW_37_260 VGND VPWR sky130_fd_sc_hd__tapvpwrvgnd_1
XTAP_TAPCELL_ROW_20_182 VGND VPWR sky130_fd_sc_hd__tapvpwrvgnd_1
X_0912_ net129 net111 VGND VGND VPWR VPWR _0246_ sky130_fd_sc_hd__nand2_1
X_0843_ _0202_ _0201_ net83 VGND VGND VPWR VPWR _0019_ sky130_fd_sc_hd__and3_1
X_0774_ product_reg\[7\] net66 _0138_ _0141_ _0139_ VGND VGND VPWR VPWR _0144_ sky130_fd_sc_hd__o2111ai_4
XTAP_TAPCELL_ROW_3_106 VGND VPWR sky130_fd_sc_hd__tapvpwrvgnd_1
X_1326_ _0600_ _0624_ _0625_ VGND VGND VPWR VPWR _0651_ sky130_fd_sc_hd__o21ai_1
X_1257_ _0582_ _0583_ VGND VGND VPWR VPWR _0584_ sky130_fd_sc_hd__nand2_1
XTAP_TAPCELL_ROW_26_208 VGND VPWR sky130_fd_sc_hd__tapvpwrvgnd_1
X_1188_ _0512_ _0515_ net85 _0084_ VGND VGND VPWR VPWR _0517_ sky130_fd_sc_hd__o211a_1
XFILLER_30_205 VGND VGND VPWR VPWR sky130_fd_sc_hd__fill_2
X_1042_ _0351_ _0356_ _0352_ _0369_ VGND VGND VPWR VPWR _0373_ sky130_fd_sc_hd__a31o_1
X_1111_ _0438_ _0364_ net117 net136 VGND VGND VPWR VPWR _0441_ sky130_fd_sc_hd__nand4_1
XTAP_TAPCELL_ROW_31_233 VGND VPWR sky130_fd_sc_hd__tapvpwrvgnd_1
X_0826_ _0180_ _0185_ _0187_ _0188_ VGND VGND VPWR VPWR _0189_ sky130_fd_sc_hd__a22oi_1
X_0688_ product_reg\[7\] VGND VGND VPWR VPWR _0068_ sky130_fd_sc_hd__inv_2
X_0757_ product_reg\[5\] net64 _0126_ _0125_ VGND VGND VPWR VPWR _0129_ sky130_fd_sc_hd__o211ai_2
X_1309_ _0611_ _0633_ VGND VGND VPWR VPWR _0634_ sky130_fd_sc_hd__nand2_1
XFILLER_38_135 VGND VGND VPWR VPWR sky130_fd_sc_hd__decap_4
X_1025_ _0295_ _0307_ _0309_ VGND VGND VPWR VPWR _0356_ sky130_fd_sc_hd__o21a_1
X_0809_ product_reg\[13\] net41 VGND VGND VPWR VPWR _0174_ sky130_fd_sc_hd__and2_1
XFILLER_29_113 VGND VGND VPWR VPWR sky130_fd_sc_hd__fill_2
XFILLER_20_83 VGND VGND VPWR VPWR sky130_fd_sc_hd__fill_1
Xrebuffer35 _0407_ VGND VGND VPWR VPWR net171 sky130_fd_sc_hd__buf_6
Xrebuffer24 _0405_ VGND VGND VPWR VPWR net160 sky130_fd_sc_hd__dlymetal6s2s_1
Xrebuffer46 _0406_ VGND VGND VPWR VPWR net182 sky130_fd_sc_hd__buf_1
Xrebuffer57 net224 VGND VGND VPWR VPWR net193 sky130_fd_sc_hd__dlymetal6s2s_1
Xrebuffer13 net153 VGND VGND VPWR VPWR net149 sky130_fd_sc_hd__clkbuf_2
Xrebuffer68 net92 VGND VGND VPWR VPWR net204 sky130_fd_sc_hd__buf_8
Xrebuffer79 net97 VGND VGND VPWR VPWR net215 sky130_fd_sc_hd__dlygate4sd1_1
X_1008_ _0335_ net149 _0302_ _0324_ _0334_ VGND VGND VPWR VPWR _0339_ sky130_fd_sc_hd__o221ai_4
XFILLER_25_39 VGND VGND VPWR VPWR sky130_fd_sc_hd__decap_4
Xrebuffer158 net295 VGND VGND VPWR VPWR net294 sky130_fd_sc_hd__dlymetal6s2s_1
Xrebuffer169 net306 VGND VGND VPWR VPWR net305 sky130_fd_sc_hd__dlygate4sd1_1
Xrebuffer147 _0103_ VGND VGND VPWR VPWR net283 sky130_fd_sc_hd__dlygate4sd1_1
XFILLER_1_248 VGND VGND VPWR VPWR sky130_fd_sc_hd__fill_1
Xoutput60 net60 VGND VGND VPWR VPWR psum[30] sky130_fd_sc_hd__buf_2
X_1290_ _0614_ _0609_ _0587_ _0586_ _0613_ VGND VGND VPWR VPWR _0616_ sky130_fd_sc_hd__a221oi_2
XFILLER_16_193 VGND VGND VPWR VPWR sky130_fd_sc_hd__decap_3
XFILLER_31_130 VGND VGND VPWR VPWR sky130_fd_sc_hd__fill_2
XFILLER_39_252 VGND VGND VPWR VPWR sky130_fd_sc_hd__fill_2
XFILLER_36_27 VGND VGND VPWR VPWR sky130_fd_sc_hd__fill_1
XTAP_TAPCELL_ROW_9_134 VGND VPWR sky130_fd_sc_hd__tapvpwrvgnd_1
XFILLER_9_101 VGND VGND VPWR VPWR sky130_fd_sc_hd__fill_1
XTAP_TAPCELL_ROW_15_158 VGND VPWR sky130_fd_sc_hd__tapvpwrvgnd_1
XFILLER_9_167 VGND VGND VPWR VPWR sky130_fd_sc_hd__fill_1
Xrebuffer4 _0427_ VGND VGND VPWR VPWR net140 sky130_fd_sc_hd__buf_6
X_0790_ product_reg\[11\] net39 VGND VGND VPWR VPWR _0157_ sky130_fd_sc_hd__or2_1
X_1411_ clknet_3_5__leaf_clk _0037_ VGND VGND VPWR VPWR net23 sky130_fd_sc_hd__dfxtp_1
X_1342_ _0615_ _0638_ _0639_ _0644_ _0664_ VGND VGND VPWR VPWR _0666_ sky130_fd_sc_hd__a311o_1
X_1273_ _0551_ _0554_ _0596_ _0597_ VGND VGND VPWR VPWR _0600_ sky130_fd_sc_hd__o211ai_1
XFILLER_22_29 VPWR VGND VPWR VGND sky130_ef_sc_hd__decap_12
X_0988_ _0281_ _0284_ _0319_ VGND VGND VPWR VPWR _0320_ sky130_fd_sc_hd__a21oi_4
Xfanout102 net104 VGND VGND VPWR VPWR net102 sky130_fd_sc_hd__buf_6
Xfanout113 net2 VGND VGND VPWR VPWR net113 sky130_fd_sc_hd__buf_2
Xfanout124 net13 VGND VGND VPWR VPWR net124 sky130_fd_sc_hd__buf_4
Xfanout135 net136 VGND VGND VPWR VPWR net135 sky130_fd_sc_hd__buf_2
XFILLER_27_200 VGND VGND VPWR VPWR sky130_fd_sc_hd__decap_4
XTAP_TAPCELL_ROW_20_183 VGND VPWR sky130_fd_sc_hd__tapvpwrvgnd_1
XPHY_EDGE_ROW_25_Left_68 VGND VGND VPWR VPWR sky130_fd_sc_hd__decap_3
X_0842_ net71 net45 net44 net46 VGND VGND VPWR VPWR _0202_ sky130_fd_sc_hd__nand4_4
X_0911_ net135 net126 VGND VGND VPWR VPWR _0245_ sky130_fd_sc_hd__nand2_1
X_0773_ _0132_ _0140_ _0141_ _0070_ VGND VGND VPWR VPWR _0143_ sky130_fd_sc_hd__a31o_1
XTAP_TAPCELL_ROW_3_107 VGND VPWR sky130_fd_sc_hd__tapvpwrvgnd_1
X_1256_ _0578_ _0579_ net99 net118 VGND VGND VPWR VPWR _0583_ sky130_fd_sc_hd__nand4_1
X_1325_ _0647_ _0648_ VGND VGND VPWR VPWR _0650_ sky130_fd_sc_hd__nor2_1
XTAP_TAPCELL_ROW_26_209 VGND VPWR sky130_fd_sc_hd__tapvpwrvgnd_1
X_1187_ _0509_ _0511_ _0514_ VGND VGND VPWR VPWR _0516_ sky130_fd_sc_hd__a21o_1
X_1110_ _0438_ _0437_ _0362_ _0365_ VGND VGND VPWR VPWR _0440_ sky130_fd_sc_hd__o2bb2ai_4
X_1041_ _0359_ _0361_ _0366_ _0367_ VGND VGND VPWR VPWR _0372_ sky130_fd_sc_hd__a22o_4
X_0825_ product_reg\[15\] net43 VGND VGND VPWR VPWR _0188_ sky130_fd_sc_hd__nand2_1
X_0687_ net319 VGND VGND VPWR VPWR _0067_ sky130_fd_sc_hd__inv_2
X_0756_ _0119_ net291 _0125_ VGND VGND VPWR VPWR _0128_ sky130_fd_sc_hd__and3_1
X_1308_ net217 net116 VGND VGND VPWR VPWR _0633_ sky130_fd_sc_hd__nand2_1
X_1239_ _0509_ _0559_ _0511_ _0561_ VGND VGND VPWR VPWR _0566_ sky130_fd_sc_hd__nand4_4
XFILLER_18_83 VGND VGND VPWR VPWR sky130_fd_sc_hd__fill_1
X_1024_ _0341_ _0347_ _0345_ _0337_ net138 VGND VGND VPWR VPWR _0355_ sky130_fd_sc_hd__o2111ai_4
XPHY_EDGE_ROW_28_Left_71 VGND VGND VPWR VPWR sky130_fd_sc_hd__decap_3
XPHY_EDGE_ROW_12_Left_55 VGND VGND VPWR VPWR sky130_fd_sc_hd__decap_3
XFILLER_30_29 VPWR VGND VPWR VGND sky130_ef_sc_hd__decap_12
X_0808_ product_reg\[13\] net41 VGND VGND VPWR VPWR _0173_ sky130_fd_sc_hd__or2_1
X_0739_ _0111_ _0112_ VGND VGND VPWR VPWR _0113_ sky130_fd_sc_hd__nand2_1
Xrebuffer69 net92 VGND VGND VPWR VPWR net205 sky130_fd_sc_hd__dlygate4sd1_1
Xrebuffer36 _0421_ VGND VGND VPWR VPWR net172 sky130_fd_sc_hd__buf_6
Xrebuffer14 net154 VGND VGND VPWR VPWR net150 sky130_fd_sc_hd__dlygate4sd1_1
X_1007_ _0302_ _0324_ _0332_ _0333_ VGND VGND VPWR VPWR _0338_ sky130_fd_sc_hd__a2bb2oi_2
Xrebuffer47 net91 VGND VGND VPWR VPWR net183 sky130_fd_sc_hd__buf_6
Xrebuffer25 _0477_ VGND VGND VPWR VPWR net161 sky130_fd_sc_hd__dlygate4sd1_1
Xrebuffer58 _0653_ VGND VGND VPWR VPWR net194 sky130_fd_sc_hd__buf_6
Xrebuffer148 net48 VGND VGND VPWR VPWR net284 sky130_fd_sc_hd__dlygate4sd1_1
Xrebuffer159 net296 VGND VGND VPWR VPWR net295 sky130_fd_sc_hd__dlygate4sd1_1
XFILLER_15_40 VGND VGND VPWR VPWR sky130_fd_sc_hd__fill_1
Xoutput50 net50 VGND VGND VPWR VPWR psum[21] sky130_fd_sc_hd__buf_2
Xoutput61 net61 VGND VGND VPWR VPWR psum[31] sky130_fd_sc_hd__buf_2
XFILLER_22_197 VGND VGND VPWR VPWR sky130_fd_sc_hd__fill_2
XFILLER_13_142 VGND VGND VPWR VPWR sky130_fd_sc_hd__fill_1
XTAP_TAPCELL_ROW_15_159 VGND VPWR sky130_fd_sc_hd__tapvpwrvgnd_1
X_1410_ clknet_3_5__leaf_clk _0036_ VGND VGND VPWR VPWR net22 sky130_fd_sc_hd__dfxtp_1
Xrebuffer5 net162 VGND VGND VPWR VPWR net141 sky130_fd_sc_hd__clkbuf_2
X_1341_ _0640_ _0644_ _0664_ VGND VGND VPWR VPWR _0665_ sky130_fd_sc_hd__o21a_1
X_1272_ _0570_ _0596_ _0597_ VGND VGND VPWR VPWR _0599_ sky130_fd_sc_hd__and3_1
X_0987_ _0314_ _0318_ _0317_ VGND VGND VPWR VPWR _0319_ sky130_fd_sc_hd__o21ai_4
Xfanout125 net128 VGND VGND VPWR VPWR net125 sky130_fd_sc_hd__buf_4
Xfanout103 net104 VGND VGND VPWR VPWR net103 sky130_fd_sc_hd__buf_6
Xfanout136 net1 VGND VGND VPWR VPWR net136 sky130_fd_sc_hd__buf_2
Xfanout114 net115 VGND VGND VPWR VPWR net114 sky130_fd_sc_hd__clkbuf_4
XTAP_TAPCELL_ROW_20_184 VGND VPWR sky130_fd_sc_hd__tapvpwrvgnd_1
Xhold190 net44 VGND VGND VPWR VPWR net326 sky130_fd_sc_hd__dlygate4sd3_1
XPHY_EDGE_ROW_0_Left_43 VGND VGND VPWR VPWR sky130_fd_sc_hd__decap_3
XPHY_EDGE_ROW_16_Right_16 VGND VGND VPWR VPWR sky130_fd_sc_hd__decap_3
X_0841_ net45 net71 net44 net46 VGND VGND VPWR VPWR _0201_ sky130_fd_sc_hd__a31o_1
X_0772_ _0132_ _0141_ _0140_ VGND VGND VPWR VPWR _0142_ sky130_fd_sc_hd__a21oi_1
XTAP_TAPCELL_ROW_11_140 VGND VPWR sky130_fd_sc_hd__tapvpwrvgnd_1
XPHY_EDGE_ROW_25_Right_25 VGND VGND VPWR VPWR sky130_fd_sc_hd__decap_3
X_0910_ net318 net83 _0085_ _0244_ VGND VGND VPWR VPWR _0045_ sky130_fd_sc_hd__a31o_1
X_1255_ net99 net118 _0578_ _0579_ VGND VGND VPWR VPWR _0582_ sky130_fd_sc_hd__a22o_1
X_1324_ _0646_ _0645_ VGND VGND VPWR VPWR _0649_ sky130_fd_sc_hd__nand2b_1
X_1186_ _0375_ _0444_ _0513_ VGND VGND VPWR VPWR _0515_ sky130_fd_sc_hd__o21ai_4
XPHY_EDGE_ROW_34_Right_34 VGND VGND VPWR VPWR sky130_fd_sc_hd__decap_3
XTAP_TAPCELL_ROW_34_243 VGND VPWR sky130_fd_sc_hd__tapvpwrvgnd_1
XPHY_EDGE_ROW_42_Left_85 VGND VGND VPWR VPWR sky130_fd_sc_hd__decap_3
X_1040_ _0359_ _0361_ _0369_ VGND VGND VPWR VPWR _0371_ sky130_fd_sc_hd__nand3_1
X_0755_ _0119_ net291 _0125_ VGND VGND VPWR VPWR _0127_ sky130_fd_sc_hd__a21oi_1
X_0824_ product_reg\[15\] net43 VGND VGND VPWR VPWR _0187_ sky130_fd_sc_hd__or2_1
X_1169_ _0491_ _0493_ _0497_ VGND VGND VPWR VPWR _0498_ sky130_fd_sc_hd__nand3_4
X_1307_ net217 net116 VGND VGND VPWR VPWR _0632_ sky130_fd_sc_hd__and2_1
X_1238_ product_reg\[9\] _0232_ _0565_ VGND VGND VPWR VPWR _0052_ sky130_fd_sc_hd__a21o_1
Xclkbuf_3_0__f_clk clknet_0_clk VGND VGND VPWR VPWR clknet_3_0__leaf_clk sky130_fd_sc_hd__clkbuf_16
XFILLER_18_51 VPWR VGND VPWR VGND sky130_ef_sc_hd__decap_12
X_1023_ _0337_ _0350_ VGND VGND VPWR VPWR _0354_ sky130_fd_sc_hd__nand2_4
X_0807_ net75 net327 net82 _0172_ VGND VGND VPWR VPWR _0013_ sky130_fd_sc_hd__o211a_1
X_0738_ product_reg\[4\] net63 VGND VGND VPWR VPWR _0112_ sky130_fd_sc_hd__or2_1
XPHY_EDGE_ROW_2_Right_2 VGND VGND VPWR VPWR sky130_fd_sc_hd__decap_3
Xrebuffer59 net88 VGND VGND VPWR VPWR net195 sky130_fd_sc_hd__dlygate4sd1_1
X_1006_ _0333_ _0332_ _0325_ VGND VGND VPWR VPWR _0337_ sky130_fd_sc_hd__nand3_4
Xrebuffer48 net183 VGND VGND VPWR VPWR net184 sky130_fd_sc_hd__dlymetal6s2s_1
Xrebuffer26 _0477_ VGND VGND VPWR VPWR net162 sky130_fd_sc_hd__buf_2
Xrebuffer15 net210 VGND VGND VPWR VPWR net151 sky130_fd_sc_hd__buf_6
Xrebuffer37 _0560_ VGND VGND VPWR VPWR net173 sky130_fd_sc_hd__buf_1
Xrebuffer149 net292 VGND VGND VPWR VPWR net285 sky130_fd_sc_hd__clkbuf_2
XFILLER_34_195 VGND VGND VPWR VPWR sky130_fd_sc_hd__fill_1
XFILLER_17_129 VGND VGND VPWR VPWR sky130_fd_sc_hd__fill_1
XFILLER_31_40 VPWR VGND VPWR VGND sky130_ef_sc_hd__decap_12
Xoutput51 net51 VGND VGND VPWR VPWR psum[22] sky130_fd_sc_hd__buf_2
Xoutput40 net40 VGND VGND VPWR VPWR psum[12] sky130_fd_sc_hd__buf_2
XTAP_TAPCELL_ROW_2_99 VGND VPWR sky130_fd_sc_hd__tapvpwrvgnd_1
Xoutput62 net62 VGND VGND VPWR VPWR psum[3] sky130_fd_sc_hd__buf_2
XFILLER_36_29 VPWR VGND VPWR VGND sky130_ef_sc_hd__decap_12
XFILLER_22_154 VGND VGND VPWR VPWR sky130_fd_sc_hd__decap_4
Xrebuffer6 _0477_ VGND VGND VPWR VPWR net142 sky130_fd_sc_hd__buf_2
X_1340_ _0658_ _0663_ VGND VGND VPWR VPWR _0664_ sky130_fd_sc_hd__xnor2_1
X_1271_ _0596_ _0597_ _0570_ VGND VGND VPWR VPWR _0598_ sky130_fd_sc_hd__a21oi_1
X_0986_ _0316_ _0275_ VGND VGND VPWR VPWR _0318_ sky130_fd_sc_hd__nand2_2
XTAP_TAPCELL_ROW_6_117 VGND VPWR sky130_fd_sc_hd__tapvpwrvgnd_1
Xfanout126 net128 VGND VGND VPWR VPWR net126 sky130_fd_sc_hd__buf_4
Xfanout104 net5 VGND VGND VPWR VPWR net104 sky130_fd_sc_hd__buf_2
Xfanout115 net16 VGND VGND VPWR VPWR net115 sky130_fd_sc_hd__buf_2
XFILLER_6_106 VGND VGND VPWR VPWR sky130_fd_sc_hd__fill_2
XFILLER_6_139 VGND VGND VPWR VPWR sky130_fd_sc_hd__fill_1
Xhold180 product_reg\[3\] VGND VGND VPWR VPWR net316 sky130_fd_sc_hd__dlygate4sd3_1
Xhold191 net40 VGND VGND VPWR VPWR net327 sky130_fd_sc_hd__dlygate4sd3_1
XFILLER_37_94 VGND VGND VPWR VPWR sky130_fd_sc_hd__fill_2
XFILLER_18_235 VGND VGND VPWR VPWR sky130_fd_sc_hd__fill_1
X_0840_ _0200_ _0199_ net83 VGND VGND VPWR VPWR _0018_ sky130_fd_sc_hd__and3_1
XTAP_TAPCELL_ROW_11_141 VGND VPWR sky130_fd_sc_hd__tapvpwrvgnd_1
X_0771_ _0068_ _0071_ _0129_ _0123_ VGND VGND VPWR VPWR _0141_ sky130_fd_sc_hd__o211ai_2
X_1323_ _0646_ _0645_ VGND VGND VPWR VPWR _0648_ sky130_fd_sc_hd__and2b_1
X_1254_ _0578_ _0579_ _0576_ VGND VGND VPWR VPWR _0581_ sky130_fd_sc_hd__a21oi_1
X_1185_ _0442_ _0446_ _0379_ _0445_ VGND VGND VPWR VPWR _0514_ sky130_fd_sc_hd__o22ai_4
XFILLER_33_19 VGND VGND VPWR VPWR sky130_fd_sc_hd__fill_1
XTAP_TAPCELL_ROW_34_244 VGND VPWR sky130_fd_sc_hd__tapvpwrvgnd_1
X_0969_ net131 net103 net147 net199 VGND VGND VPWR VPWR _0301_ sky130_fd_sc_hd__a22o_1
XFILLER_23_41 VGND VGND VPWR VPWR sky130_fd_sc_hd__fill_1
XFILLER_23_74 VPWR VGND VPWR VGND sky130_ef_sc_hd__decap_12
X_0823_ net75 net335 net81 _0186_ VGND VGND VPWR VPWR _0015_ sky130_fd_sc_hd__o211a_1
X_0754_ _0069_ _0072_ _0113_ _0110_ _0111_ VGND VGND VPWR VPWR _0126_ sky130_fd_sc_hd__o221ai_4
X_1306_ _0607_ _0609_ VGND VGND VPWR VPWR _0631_ sky130_fd_sc_hd__nand2_1
XFILLER_28_19 VGND VGND VPWR VPWR sky130_fd_sc_hd__decap_4
X_1099_ _0425_ _0422_ _0426_ VGND VGND VPWR VPWR _0429_ sky130_fd_sc_hd__a21oi_2
X_1168_ _0392_ net206 net170 VGND VGND VPWR VPWR _0497_ sky130_fd_sc_hd__o21ai_2
X_1237_ _0558_ net173 _0563_ _0000_ _0564_ VGND VGND VPWR VPWR _0565_ sky130_fd_sc_hd__o311a_1
XFILLER_18_63 VPWR VGND VPWR VGND sky130_ef_sc_hd__decap_12
XFILLER_18_85 VGND VGND VPWR VPWR sky130_fd_sc_hd__fill_1
XFILLER_7_212 VGND VGND VPWR VPWR sky130_fd_sc_hd__fill_1
X_1022_ _0337_ _0339_ _0344_ _0348_ VGND VGND VPWR VPWR _0353_ sky130_fd_sc_hd__o2bb2ai_2
X_0737_ product_reg\[4\] net63 VGND VGND VPWR VPWR _0111_ sky130_fd_sc_hd__nand2_2
X_0806_ _0170_ _0171_ _0070_ VGND VGND VPWR VPWR _0172_ sky130_fd_sc_hd__a21o_1
XFILLER_37_182 VGND VGND VPWR VPWR sky130_fd_sc_hd__fill_1
XFILLER_4_215 VGND VGND VPWR VPWR sky130_fd_sc_hd__fill_2
XFILLER_28_160 VGND VGND VPWR VPWR sky130_fd_sc_hd__decap_3
Xrebuffer27 _0477_ VGND VGND VPWR VPWR net163 sky130_fd_sc_hd__clkbuf_2
Xrebuffer16 _0498_ VGND VGND VPWR VPWR net152 sky130_fd_sc_hd__buf_8
X_1005_ net150 _0335_ _0334_ VGND VGND VPWR VPWR _0336_ sky130_fd_sc_hd__o21ai_1
Xrebuffer49 net98 VGND VGND VPWR VPWR net185 sky130_fd_sc_hd__buf_4
Xrebuffer38 net173 VGND VGND VPWR VPWR net174 sky130_fd_sc_hd__dlymetal6s2s_1
XFILLER_40_177 VGND VGND VPWR VPWR sky130_fd_sc_hd__fill_2
XFILLER_40_166 VGND VGND VPWR VPWR sky130_fd_sc_hd__decap_3
Xoutput52 net52 VGND VGND VPWR VPWR psum[23] sky130_fd_sc_hd__buf_2
Xoutput30 net30 VGND VGND VPWR VPWR b_out[1] sky130_fd_sc_hd__buf_2
XFILLER_31_52 VGND VGND VPWR VPWR sky130_fd_sc_hd__decap_4
Xoutput41 net41 VGND VGND VPWR VPWR psum[13] sky130_fd_sc_hd__buf_2
XFILLER_0_251 VGND VGND VPWR VPWR sky130_fd_sc_hd__fill_1
Xoutput63 net63 VGND VGND VPWR VPWR psum[4] sky130_fd_sc_hd__buf_2
XFILLER_31_111 VGND VGND VPWR VPWR sky130_fd_sc_hd__fill_1
XFILLER_31_166 VGND VGND VPWR VPWR sky130_fd_sc_hd__fill_2
.ends
