* NGSPICE file created from PE.ext - technology: sky130A

* Black-box entry subcircuit for sky130_fd_sc_hd__fill_2 abstract view
.subckt sky130_fd_sc_hd__fill_2 VGND VNB VPB VPWR
.ends

* Black-box entry subcircuit for sky130_fd_sc_hd__tapvpwrvgnd_1 abstract view
.subckt sky130_fd_sc_hd__tapvpwrvgnd_1 VGND VPWR
.ends

* Black-box entry subcircuit for sky130_ef_sc_hd__decap_12 abstract view
.subckt sky130_ef_sc_hd__decap_12 VPWR VGND VPB VNB
.ends

* Black-box entry subcircuit for sky130_fd_sc_hd__decap_4 abstract view
.subckt sky130_fd_sc_hd__decap_4 VGND VNB VPB VPWR
.ends

* Black-box entry subcircuit for sky130_fd_sc_hd__clkbuf_1 abstract view
.subckt sky130_fd_sc_hd__clkbuf_1 A VGND VNB VPB VPWR X
.ends

* Black-box entry subcircuit for sky130_fd_sc_hd__o21ai_1 abstract view
.subckt sky130_fd_sc_hd__o21ai_1 A1 A2 B1 VGND VNB VPB VPWR Y
.ends

* Black-box entry subcircuit for sky130_fd_sc_hd__o2bb2ai_2 abstract view
.subckt sky130_fd_sc_hd__o2bb2ai_2 A1_N A2_N B1 B2 VGND VNB VPB VPWR Y
.ends

* Black-box entry subcircuit for sky130_fd_sc_hd__buf_4 abstract view
.subckt sky130_fd_sc_hd__buf_4 A VGND VNB VPB VPWR X
.ends

* Black-box entry subcircuit for sky130_fd_sc_hd__dfxtp_1 abstract view
.subckt sky130_fd_sc_hd__dfxtp_1 CLK D VGND VNB VPB VPWR Q
.ends

* Black-box entry subcircuit for sky130_fd_sc_hd__clkbuf_4 abstract view
.subckt sky130_fd_sc_hd__clkbuf_4 A VGND VNB VPB VPWR X
.ends

* Black-box entry subcircuit for sky130_fd_sc_hd__decap_3 abstract view
.subckt sky130_fd_sc_hd__decap_3 VGND VNB VPB VPWR
.ends

* Black-box entry subcircuit for sky130_fd_sc_hd__decap_8 abstract view
.subckt sky130_fd_sc_hd__decap_8 VGND VNB VPB VPWR
.ends

* Black-box entry subcircuit for sky130_fd_sc_hd__dlygate4sd3_1 abstract view
.subckt sky130_fd_sc_hd__dlygate4sd3_1 A VGND VNB VPB VPWR X
.ends

* Black-box entry subcircuit for sky130_fd_sc_hd__nand2_1 abstract view
.subckt sky130_fd_sc_hd__nand2_1 A B VGND VNB VPB VPWR Y
.ends

* Black-box entry subcircuit for sky130_fd_sc_hd__and3_1 abstract view
.subckt sky130_fd_sc_hd__and3_1 A B C VGND VNB VPB VPWR X
.ends

* Black-box entry subcircuit for sky130_fd_sc_hd__a211oi_2 abstract view
.subckt sky130_fd_sc_hd__a211oi_2 A1 A2 B1 C1 VGND VNB VPB VPWR Y
.ends

* Black-box entry subcircuit for sky130_fd_sc_hd__a22oi_4 abstract view
.subckt sky130_fd_sc_hd__a22oi_4 A1 A2 B1 B2 VGND VNB VPB VPWR Y
.ends

* Black-box entry subcircuit for sky130_fd_sc_hd__a22o_1 abstract view
.subckt sky130_fd_sc_hd__a22o_1 A1 A2 B1 B2 VGND VNB VPB VPWR X
.ends

* Black-box entry subcircuit for sky130_fd_sc_hd__a21o_1 abstract view
.subckt sky130_fd_sc_hd__a21o_1 A1 A2 B1 VGND VNB VPB VPWR X
.ends

* Black-box entry subcircuit for sky130_fd_sc_hd__and2_1 abstract view
.subckt sky130_fd_sc_hd__and2_1 A B VGND VNB VPB VPWR X
.ends

* Black-box entry subcircuit for sky130_fd_sc_hd__a21oi_1 abstract view
.subckt sky130_fd_sc_hd__a21oi_1 A1 A2 B1 VGND VNB VPB VPWR Y
.ends

* Black-box entry subcircuit for sky130_fd_sc_hd__o211ai_2 abstract view
.subckt sky130_fd_sc_hd__o211ai_2 A1 A2 B1 C1 VGND VNB VPB VPWR Y
.ends

* Black-box entry subcircuit for sky130_fd_sc_hd__o211ai_4 abstract view
.subckt sky130_fd_sc_hd__o211ai_4 A1 A2 B1 C1 VGND VNB VPB VPWR Y
.ends

* Black-box entry subcircuit for sky130_fd_sc_hd__fill_1 abstract view
.subckt sky130_fd_sc_hd__fill_1 VGND VNB VPB VPWR
.ends

* Black-box entry subcircuit for sky130_fd_sc_hd__a21oi_4 abstract view
.subckt sky130_fd_sc_hd__a21oi_4 A1 A2 B1 VGND VNB VPB VPWR Y
.ends

* Black-box entry subcircuit for sky130_fd_sc_hd__o21bai_2 abstract view
.subckt sky130_fd_sc_hd__o21bai_2 A1 A2 B1_N VGND VNB VPB VPWR Y
.ends

* Black-box entry subcircuit for sky130_fd_sc_hd__buf_6 abstract view
.subckt sky130_fd_sc_hd__buf_6 A VGND VNB VPB VPWR X
.ends

* Black-box entry subcircuit for sky130_fd_sc_hd__dlygate4sd1_1 abstract view
.subckt sky130_fd_sc_hd__dlygate4sd1_1 A VGND VNB VPB VPWR X
.ends

* Black-box entry subcircuit for sky130_fd_sc_hd__dlymetal6s2s_1 abstract view
.subckt sky130_fd_sc_hd__dlymetal6s2s_1 A VGND VNB VPB VPWR X
.ends

* Black-box entry subcircuit for sky130_fd_sc_hd__decap_6 abstract view
.subckt sky130_fd_sc_hd__decap_6 VGND VNB VPB VPWR
.ends

* Black-box entry subcircuit for sky130_fd_sc_hd__a41o_1 abstract view
.subckt sky130_fd_sc_hd__a41o_1 A1 A2 A3 A4 B1 VGND VNB VPB VPWR X
.ends

* Black-box entry subcircuit for sky130_fd_sc_hd__buf_2 abstract view
.subckt sky130_fd_sc_hd__buf_2 A VGND VNB VPB VPWR X
.ends

* Black-box entry subcircuit for sky130_fd_sc_hd__clkbuf_16 abstract view
.subckt sky130_fd_sc_hd__clkbuf_16 A VGND VNB VPB VPWR X
.ends

* Black-box entry subcircuit for sky130_fd_sc_hd__clkbuf_2 abstract view
.subckt sky130_fd_sc_hd__clkbuf_2 A VGND VNB VPB VPWR X
.ends

* Black-box entry subcircuit for sky130_fd_sc_hd__nand3_2 abstract view
.subckt sky130_fd_sc_hd__nand3_2 A B C VGND VNB VPB VPWR Y
.ends

* Black-box entry subcircuit for sky130_fd_sc_hd__buf_12 abstract view
.subckt sky130_fd_sc_hd__buf_12 A VGND VNB VPB VPWR X
.ends

* Black-box entry subcircuit for sky130_fd_sc_hd__nand4_4 abstract view
.subckt sky130_fd_sc_hd__nand4_4 A B C D VGND VNB VPB VPWR Y
.ends

* Black-box entry subcircuit for sky130_fd_sc_hd__o21ai_2 abstract view
.subckt sky130_fd_sc_hd__o21ai_2 A1 A2 B1 VGND VNB VPB VPWR Y
.ends

* Black-box entry subcircuit for sky130_fd_sc_hd__nand4_1 abstract view
.subckt sky130_fd_sc_hd__nand4_1 A B C D VGND VNB VPB VPWR Y
.ends

* Black-box entry subcircuit for sky130_fd_sc_hd__or2_1 abstract view
.subckt sky130_fd_sc_hd__or2_1 A B VGND VNB VPB VPWR X
.ends

* Black-box entry subcircuit for sky130_fd_sc_hd__o21a_1 abstract view
.subckt sky130_fd_sc_hd__o21a_1 A1 A2 B1 VGND VNB VPB VPWR X
.ends

* Black-box entry subcircuit for sky130_fd_sc_hd__a21o_4 abstract view
.subckt sky130_fd_sc_hd__a21o_4 A1 A2 B1 VGND VNB VPB VPWR X
.ends

* Black-box entry subcircuit for sky130_fd_sc_hd__o2111ai_4 abstract view
.subckt sky130_fd_sc_hd__o2111ai_4 A1 A2 B1 C1 D1 VGND VNB VPB VPWR Y
.ends

* Black-box entry subcircuit for sky130_fd_sc_hd__o211a_1 abstract view
.subckt sky130_fd_sc_hd__o211a_1 A1 A2 B1 C1 VGND VNB VPB VPWR X
.ends

* Black-box entry subcircuit for sky130_fd_sc_hd__a21oi_2 abstract view
.subckt sky130_fd_sc_hd__a21oi_2 A1 A2 B1 VGND VNB VPB VPWR Y
.ends

* Black-box entry subcircuit for sky130_fd_sc_hd__nor2_1 abstract view
.subckt sky130_fd_sc_hd__nor2_1 A B VGND VNB VPB VPWR Y
.ends

* Black-box entry subcircuit for sky130_fd_sc_hd__a22o_2 abstract view
.subckt sky130_fd_sc_hd__a22o_2 A1 A2 B1 B2 VGND VNB VPB VPWR X
.ends

* Black-box entry subcircuit for sky130_fd_sc_hd__o22a_1 abstract view
.subckt sky130_fd_sc_hd__o22a_1 A1 A2 B1 B2 VGND VNB VPB VPWR X
.ends

* Black-box entry subcircuit for sky130_fd_sc_hd__a211o_1 abstract view
.subckt sky130_fd_sc_hd__a211o_1 A1 A2 B1 C1 VGND VNB VPB VPWR X
.ends

* Black-box entry subcircuit for sky130_fd_sc_hd__nor2_2 abstract view
.subckt sky130_fd_sc_hd__nor2_2 A B VGND VNB VPB VPWR Y
.ends

* Black-box entry subcircuit for sky130_fd_sc_hd__o21ai_4 abstract view
.subckt sky130_fd_sc_hd__o21ai_4 A1 A2 B1 VGND VNB VPB VPWR Y
.ends

* Black-box entry subcircuit for sky130_fd_sc_hd__a22oi_2 abstract view
.subckt sky130_fd_sc_hd__a22oi_2 A1 A2 B1 B2 VGND VNB VPB VPWR Y
.ends

* Black-box entry subcircuit for sky130_fd_sc_hd__buf_8 abstract view
.subckt sky130_fd_sc_hd__buf_8 A VGND VNB VPB VPWR X
.ends

* Black-box entry subcircuit for sky130_fd_sc_hd__a2111oi_1 abstract view
.subckt sky130_fd_sc_hd__a2111oi_1 A1 A2 B1 C1 D1 VGND VNB VPB VPWR Y
.ends

* Black-box entry subcircuit for sky130_fd_sc_hd__o221ai_4 abstract view
.subckt sky130_fd_sc_hd__o221ai_4 A1 A2 B1 B2 C1 VGND VNB VPB VPWR Y
.ends

* Black-box entry subcircuit for sky130_fd_sc_hd__o211ai_1 abstract view
.subckt sky130_fd_sc_hd__o211ai_1 A1 A2 B1 C1 VGND VNB VPB VPWR Y
.ends

* Black-box entry subcircuit for sky130_fd_sc_hd__nand3_1 abstract view
.subckt sky130_fd_sc_hd__nand3_1 A B C VGND VNB VPB VPWR Y
.ends

* Black-box entry subcircuit for sky130_fd_sc_hd__nand4_2 abstract view
.subckt sky130_fd_sc_hd__nand4_2 A B C D VGND VNB VPB VPWR Y
.ends

* Black-box entry subcircuit for sky130_fd_sc_hd__and4_1 abstract view
.subckt sky130_fd_sc_hd__and4_1 A B C D VGND VNB VPB VPWR X
.ends

* Black-box entry subcircuit for sky130_fd_sc_hd__nand2_2 abstract view
.subckt sky130_fd_sc_hd__nand2_2 A B VGND VNB VPB VPWR Y
.ends

* Black-box entry subcircuit for sky130_fd_sc_hd__o22ai_2 abstract view
.subckt sky130_fd_sc_hd__o22ai_2 A1 A2 B1 B2 VGND VNB VPB VPWR Y
.ends

* Black-box entry subcircuit for sky130_fd_sc_hd__clkbuf_8 abstract view
.subckt sky130_fd_sc_hd__clkbuf_8 A VGND VNB VPB VPWR X
.ends

* Black-box entry subcircuit for sky130_fd_sc_hd__nand3_4 abstract view
.subckt sky130_fd_sc_hd__nand3_4 A B C VGND VNB VPB VPWR Y
.ends

* Black-box entry subcircuit for sky130_fd_sc_hd__a22oi_1 abstract view
.subckt sky130_fd_sc_hd__a22oi_1 A1 A2 B1 B2 VGND VNB VPB VPWR Y
.ends

* Black-box entry subcircuit for sky130_fd_sc_hd__nand2_4 abstract view
.subckt sky130_fd_sc_hd__nand2_4 A B VGND VNB VPB VPWR Y
.ends

* Black-box entry subcircuit for sky130_fd_sc_hd__nand2b_1 abstract view
.subckt sky130_fd_sc_hd__nand2b_1 A_N B VGND VNB VPB VPWR Y
.ends

* Black-box entry subcircuit for sky130_fd_sc_hd__a22o_4 abstract view
.subckt sky130_fd_sc_hd__a22o_4 A1 A2 B1 B2 VGND VNB VPB VPWR X
.ends

* Black-box entry subcircuit for sky130_fd_sc_hd__clkinvlp_4 abstract view
.subckt sky130_fd_sc_hd__clkinvlp_4 A VGND VNB VPB VPWR Y
.ends

* Black-box entry subcircuit for sky130_fd_sc_hd__o22ai_4 abstract view
.subckt sky130_fd_sc_hd__o22ai_4 A1 A2 B1 B2 VGND VNB VPB VPWR Y
.ends

* Black-box entry subcircuit for sky130_fd_sc_hd__dfxtp_4 abstract view
.subckt sky130_fd_sc_hd__dfxtp_4 CLK D VGND VNB VPB VPWR Q
.ends

* Black-box entry subcircuit for sky130_fd_sc_hd__o2bb2ai_1 abstract view
.subckt sky130_fd_sc_hd__o2bb2ai_1 A1_N A2_N B1 B2 VGND VNB VPB VPWR Y
.ends

* Black-box entry subcircuit for sky130_fd_sc_hd__o2111a_1 abstract view
.subckt sky130_fd_sc_hd__o2111a_1 A1 A2 B1 C1 D1 VGND VNB VPB VPWR X
.ends

* Black-box entry subcircuit for sky130_fd_sc_hd__clkinv_4 abstract view
.subckt sky130_fd_sc_hd__clkinv_4 A VGND VNB VPB VPWR Y
.ends

* Black-box entry subcircuit for sky130_fd_sc_hd__a2bb2oi_2 abstract view
.subckt sky130_fd_sc_hd__a2bb2oi_2 A1_N A2_N B1 B2 VGND VNB VPB VPWR Y
.ends

* Black-box entry subcircuit for sky130_fd_sc_hd__o211a_4 abstract view
.subckt sky130_fd_sc_hd__o211a_4 A1 A2 B1 C1 VGND VNB VPB VPWR X
.ends

* Black-box entry subcircuit for sky130_fd_sc_hd__a31o_1 abstract view
.subckt sky130_fd_sc_hd__a31o_1 A1 A2 A3 B1 VGND VNB VPB VPWR X
.ends

* Black-box entry subcircuit for sky130_fd_sc_hd__o2bb2a_2 abstract view
.subckt sky130_fd_sc_hd__o2bb2a_2 A1_N A2_N B1 B2 VGND VNB VPB VPWR X
.ends

* Black-box entry subcircuit for sky130_fd_sc_hd__dfxtp_2 abstract view
.subckt sky130_fd_sc_hd__dfxtp_2 CLK D VGND VNB VPB VPWR Q
.ends

* Black-box entry subcircuit for sky130_fd_sc_hd__o2111ai_2 abstract view
.subckt sky130_fd_sc_hd__o2111ai_2 A1 A2 B1 C1 D1 VGND VNB VPB VPWR Y
.ends

* Black-box entry subcircuit for sky130_fd_sc_hd__bufinv_16 abstract view
.subckt sky130_fd_sc_hd__bufinv_16 A VGND VNB VPB VPWR Y
.ends

* Black-box entry subcircuit for sky130_fd_sc_hd__inv_2 abstract view
.subckt sky130_fd_sc_hd__inv_2 A VGND VNB VPB VPWR Y
.ends

* Black-box entry subcircuit for sky130_fd_sc_hd__o2bb2ai_4 abstract view
.subckt sky130_fd_sc_hd__o2bb2ai_4 A1_N A2_N B1 B2 VGND VNB VPB VPWR Y
.ends

* Black-box entry subcircuit for sky130_fd_sc_hd__o311a_4 abstract view
.subckt sky130_fd_sc_hd__o311a_4 A1 A2 A3 B1 C1 VGND VNB VPB VPWR X
.ends

* Black-box entry subcircuit for sky130_fd_sc_hd__clkinv_2 abstract view
.subckt sky130_fd_sc_hd__clkinv_2 A VGND VNB VPB VPWR Y
.ends

* Black-box entry subcircuit for sky130_fd_sc_hd__and4b_1 abstract view
.subckt sky130_fd_sc_hd__and4b_1 A_N B C D VGND VNB VPB VPWR X
.ends

* Black-box entry subcircuit for sky130_fd_sc_hd__o31a_1 abstract view
.subckt sky130_fd_sc_hd__o31a_1 A1 A2 A3 B1 VGND VNB VPB VPWR X
.ends

* Black-box entry subcircuit for sky130_fd_sc_hd__or4b_1 abstract view
.subckt sky130_fd_sc_hd__or4b_1 A B C D_N VGND VNB VPB VPWR X
.ends

* Black-box entry subcircuit for sky130_fd_sc_hd__nand3b_1 abstract view
.subckt sky130_fd_sc_hd__nand3b_1 A_N B C VGND VNB VPB VPWR Y
.ends

* Black-box entry subcircuit for sky130_fd_sc_hd__and4_2 abstract view
.subckt sky130_fd_sc_hd__and4_2 A B C D VGND VNB VPB VPWR X
.ends

* Black-box entry subcircuit for sky130_fd_sc_hd__nor3_2 abstract view
.subckt sky130_fd_sc_hd__nor3_2 A B C VGND VNB VPB VPWR Y
.ends

* Black-box entry subcircuit for sky130_fd_sc_hd__xor2_1 abstract view
.subckt sky130_fd_sc_hd__xor2_1 A B VGND VNB VPB VPWR X
.ends

* Black-box entry subcircuit for sky130_fd_sc_hd__a2bb2o_1 abstract view
.subckt sky130_fd_sc_hd__a2bb2o_1 A1_N A2_N B1 B2 VGND VNB VPB VPWR X
.ends

* Black-box entry subcircuit for sky130_fd_sc_hd__a31oi_2 abstract view
.subckt sky130_fd_sc_hd__a31oi_2 A1 A2 A3 B1 VGND VNB VPB VPWR Y
.ends

* Black-box entry subcircuit for sky130_fd_sc_hd__inv_4 abstract view
.subckt sky130_fd_sc_hd__inv_4 A VGND VNB VPB VPWR Y
.ends

* Black-box entry subcircuit for sky130_fd_sc_hd__a311oi_1 abstract view
.subckt sky130_fd_sc_hd__a311oi_1 A1 A2 A3 B1 C1 VGND VNB VPB VPWR Y
.ends

* Black-box entry subcircuit for sky130_fd_sc_hd__a31oi_1 abstract view
.subckt sky130_fd_sc_hd__a31oi_1 A1 A2 A3 B1 VGND VNB VPB VPWR Y
.ends

* Black-box entry subcircuit for sky130_fd_sc_hd__a311o_1 abstract view
.subckt sky130_fd_sc_hd__a311o_1 A1 A2 A3 B1 C1 VGND VNB VPB VPWR X
.ends

* Black-box entry subcircuit for sky130_fd_sc_hd__a41oi_2 abstract view
.subckt sky130_fd_sc_hd__a41oi_2 A1 A2 A3 A4 B1 VGND VNB VPB VPWR Y
.ends

* Black-box entry subcircuit for sky130_fd_sc_hd__or4_4 abstract view
.subckt sky130_fd_sc_hd__or4_4 A B C D VGND VNB VPB VPWR X
.ends

* Black-box entry subcircuit for sky130_fd_sc_hd__a32oi_4 abstract view
.subckt sky130_fd_sc_hd__a32oi_4 A1 A2 A3 B1 B2 VGND VNB VPB VPWR Y
.ends

* Black-box entry subcircuit for sky130_fd_sc_hd__a21boi_4 abstract view
.subckt sky130_fd_sc_hd__a21boi_4 A1 A2 B1_N VGND VNB VPB VPWR Y
.ends

* Black-box entry subcircuit for sky130_fd_sc_hd__o32ai_2 abstract view
.subckt sky130_fd_sc_hd__o32ai_2 A1 A2 A3 B1 B2 VGND VNB VPB VPWR Y
.ends

* Black-box entry subcircuit for sky130_fd_sc_hd__o21a_4 abstract view
.subckt sky130_fd_sc_hd__o21a_4 A1 A2 B1 VGND VNB VPB VPWR X
.ends

* Black-box entry subcircuit for sky130_fd_sc_hd__o41ai_4 abstract view
.subckt sky130_fd_sc_hd__o41ai_4 A1 A2 A3 A4 B1 VGND VNB VPB VPWR Y
.ends

* Black-box entry subcircuit for sky130_fd_sc_hd__or3_1 abstract view
.subckt sky130_fd_sc_hd__or3_1 A B C VGND VNB VPB VPWR X
.ends

* Black-box entry subcircuit for sky130_fd_sc_hd__o21bai_1 abstract view
.subckt sky130_fd_sc_hd__o21bai_1 A1 A2 B1_N VGND VNB VPB VPWR Y
.ends

* Black-box entry subcircuit for sky130_fd_sc_hd__a32o_1 abstract view
.subckt sky130_fd_sc_hd__a32o_1 A1 A2 A3 B1 B2 VGND VNB VPB VPWR X
.ends

* Black-box entry subcircuit for sky130_fd_sc_hd__o221a_4 abstract view
.subckt sky130_fd_sc_hd__o221a_4 A1 A2 B1 B2 C1 VGND VNB VPB VPWR X
.ends

* Black-box entry subcircuit for sky130_fd_sc_hd__buf_1 abstract view
.subckt sky130_fd_sc_hd__buf_1 A VGND VNB VPB VPWR X
.ends

* Black-box entry subcircuit for sky130_fd_sc_hd__a2bb2oi_1 abstract view
.subckt sky130_fd_sc_hd__a2bb2oi_1 A1_N A2_N B1 B2 VGND VNB VPB VPWR Y
.ends

* Black-box entry subcircuit for sky130_fd_sc_hd__o31ai_4 abstract view
.subckt sky130_fd_sc_hd__o31ai_4 A1 A2 A3 B1 VGND VNB VPB VPWR Y
.ends

* Black-box entry subcircuit for sky130_fd_sc_hd__and3_4 abstract view
.subckt sky130_fd_sc_hd__and3_4 A B C VGND VNB VPB VPWR X
.ends

* Black-box entry subcircuit for sky130_fd_sc_hd__nand3b_4 abstract view
.subckt sky130_fd_sc_hd__nand3b_4 A_N B C VGND VNB VPB VPWR Y
.ends

* Black-box entry subcircuit for sky130_fd_sc_hd__a2bb2o_4 abstract view
.subckt sky130_fd_sc_hd__a2bb2o_4 A1_N A2_N B1 B2 VGND VNB VPB VPWR X
.ends

* Black-box entry subcircuit for sky130_fd_sc_hd__dlymetal6s4s_1 abstract view
.subckt sky130_fd_sc_hd__dlymetal6s4s_1 A VGND VNB VPB VPWR X
.ends

* Black-box entry subcircuit for sky130_fd_sc_hd__a2bb2o_2 abstract view
.subckt sky130_fd_sc_hd__a2bb2o_2 A1_N A2_N B1 B2 VGND VNB VPB VPWR X
.ends

* Black-box entry subcircuit for sky130_fd_sc_hd__o2bb2a_1 abstract view
.subckt sky130_fd_sc_hd__o2bb2a_1 A1_N A2_N B1 B2 VGND VNB VPB VPWR X
.ends

* Black-box entry subcircuit for sky130_fd_sc_hd__or3_2 abstract view
.subckt sky130_fd_sc_hd__or3_2 A B C VGND VNB VPB VPWR X
.ends

* Black-box entry subcircuit for sky130_fd_sc_hd__a221o_1 abstract view
.subckt sky130_fd_sc_hd__a221o_1 A1 A2 B1 B2 C1 VGND VNB VPB VPWR X
.ends

* Black-box entry subcircuit for sky130_fd_sc_hd__a41oi_1 abstract view
.subckt sky130_fd_sc_hd__a41oi_1 A1 A2 A3 A4 B1 VGND VNB VPB VPWR Y
.ends

* Black-box entry subcircuit for sky130_fd_sc_hd__and4_4 abstract view
.subckt sky130_fd_sc_hd__and4_4 A B C D VGND VNB VPB VPWR X
.ends

* Black-box entry subcircuit for sky130_fd_sc_hd__nand4b_2 abstract view
.subckt sky130_fd_sc_hd__nand4b_2 A_N B C D VGND VNB VPB VPWR Y
.ends

* Black-box entry subcircuit for sky130_fd_sc_hd__xnor2_1 abstract view
.subckt sky130_fd_sc_hd__xnor2_1 A B VGND VNB VPB VPWR Y
.ends

* Black-box entry subcircuit for sky130_fd_sc_hd__nor3b_1 abstract view
.subckt sky130_fd_sc_hd__nor3b_1 A B C_N VGND VNB VPB VPWR Y
.ends

* Black-box entry subcircuit for sky130_fd_sc_hd__nand3b_2 abstract view
.subckt sky130_fd_sc_hd__nand3b_2 A_N B C VGND VNB VPB VPWR Y
.ends

* Black-box entry subcircuit for sky130_fd_sc_hd__nor4_2 abstract view
.subckt sky130_fd_sc_hd__nor4_2 A B C D VGND VNB VPB VPWR Y
.ends

* Black-box entry subcircuit for sky130_fd_sc_hd__o311a_1 abstract view
.subckt sky130_fd_sc_hd__o311a_1 A1 A2 A3 B1 C1 VGND VNB VPB VPWR X
.ends

* Black-box entry subcircuit for sky130_fd_sc_hd__o41ai_1 abstract view
.subckt sky130_fd_sc_hd__o41ai_1 A1 A2 A3 A4 B1 VGND VNB VPB VPWR Y
.ends

* Black-box entry subcircuit for sky130_fd_sc_hd__o221a_1 abstract view
.subckt sky130_fd_sc_hd__o221a_1 A1 A2 B1 B2 C1 VGND VNB VPB VPWR X
.ends

* Black-box entry subcircuit for sky130_fd_sc_hd__a221oi_4 abstract view
.subckt sky130_fd_sc_hd__a221oi_4 A1 A2 B1 B2 C1 VGND VNB VPB VPWR Y
.ends

* Black-box entry subcircuit for sky130_fd_sc_hd__and2b_1 abstract view
.subckt sky130_fd_sc_hd__and2b_1 A_N B VGND VNB VPB VPWR X
.ends

.subckt PE VGND VPWR a_in[0] a_in[1] a_in[2] a_in[3] a_in[4] a_in[5] a_in[6] a_in[7]
+ a_out[0] a_out[1] a_out[2] a_out[3] a_out[4] a_out[5] a_out[6] a_out[7] b_in[0]
+ b_in[1] b_in[2] b_in[3] b_in[4] b_in[5] b_in[6] b_in[7] b_out[0] b_out[1] b_out[2]
+ b_out[3] b_out[4] b_out[5] b_out[6] b_out[7] clear_acc clk psum[0] psum[10] psum[11]
+ psum[12] psum[13] psum[14] psum[15] psum[16] psum[17] psum[18] psum[19] psum[1]
+ psum[20] psum[21] psum[22] psum[23] psum[24] psum[25] psum[26] psum[27] psum[28]
+ psum[29] psum[2] psum[30] psum[31] psum[3] psum[4] psum[5] psum[6] psum[7] psum[8]
+ psum[9] reset v_a_in v_a_out v_b_in v_b_out
XFILLER_39_222 VGND VGND VPWR VPWR sky130_fd_sc_hd__fill_2
XTAP_TAPCELL_ROW_52_404 VGND VPWR sky130_fd_sc_hd__tapvpwrvgnd_1
XFILLER_52_29 VPWR VGND VPWR VGND sky130_ef_sc_hd__decap_12
XFILLER_45_225 VGND VGND VPWR VPWR sky130_fd_sc_hd__decap_4
XFILLER_26_85 VPWR VGND VPWR VGND sky130_ef_sc_hd__decap_12
XFILLER_13_166 VGND VGND VPWR VPWR sky130_fd_sc_hd__fill_2
Xrebuffer7 _0427_ VGND VGND VPWR VPWR net139 sky130_fd_sc_hd__clkbuf_1
XFILLER_36_214 VPWR VGND VPWR VGND sky130_ef_sc_hd__decap_12
X_1270_ _0591_ _0593_ _0595_ VGND VGND VPWR VPWR _0597_ sky130_fd_sc_hd__o21ai_1
X_0985_ _0315_ _0316_ _0245_ net336 VGND VGND VPWR VPWR _0317_ sky130_fd_sc_hd__o2bb2ai_2
Xfanout127 net11 VGND VGND VPWR VPWR net127 sky130_fd_sc_hd__buf_4
X_1399_ clknet_3_6__leaf_clk _0025_ VGND VGND VPWR VPWR net53 sky130_fd_sc_hd__dfxtp_1
Xfanout105 net4 VGND VGND VPWR VPWR net105 sky130_fd_sc_hd__clkbuf_4
Xfanout116 net118 VGND VGND VPWR VPWR net116 sky130_fd_sc_hd__clkbuf_4
XPHY_EDGE_ROW_19_Left_72 VGND VGND VPWR VPWR sky130_fd_sc_hd__decap_3
XFILLER_27_225 VGND VGND VPWR VPWR sky130_fd_sc_hd__decap_8
XFILLER_6_129 VGND VGND VPWR VPWR sky130_fd_sc_hd__decap_4
Xhold192 _0633_ VGND VGND VPWR VPWR net324 sky130_fd_sc_hd__dlygate4sd3_1
XTAP_TAPCELL_ROW_5_140 VGND VPWR sky130_fd_sc_hd__tapvpwrvgnd_1
XFILLER_41_261 VPWR VGND VPWR VGND sky130_ef_sc_hd__decap_12
XTAP_TAPCELL_ROW_11_175 VGND VPWR sky130_fd_sc_hd__tapvpwrvgnd_1
X_0770_ _0138_ _0139_ VGND VGND VPWR VPWR _0140_ sky130_fd_sc_hd__nand2_1
X_1253_ _0576_ _0578_ _0579_ VGND VGND VPWR VPWR _0580_ sky130_fd_sc_hd__and3_1
X_1322_ _0620_ _0618_ _0616_ _0645_ VGND VGND VPWR VPWR _0647_ sky130_fd_sc_hd__a211oi_2
X_1184_ _0321_ _0377_ _0447_ VGND VGND VPWR VPWR _0513_ sky130_fd_sc_hd__o21ai_1
XTAP_TAPCELL_ROW_19_220 VGND VPWR sky130_fd_sc_hd__tapvpwrvgnd_1
X_0968_ net128 net102 net100 net88 VGND VGND VPWR VPWR _0300_ sky130_fd_sc_hd__a22oi_4
X_0899_ net330 net333 net131 net312 VGND VGND VPWR VPWR _0235_ sky130_fd_sc_hd__a22o_1
XPHY_EDGE_ROW_4_Left_57 VGND VGND VPWR VPWR sky130_fd_sc_hd__decap_3
XFILLER_38_309 VGND VGND VPWR VPWR sky130_fd_sc_hd__fill_2
XFILLER_0_57 VGND VGND VPWR VPWR sky130_fd_sc_hd__fill_2
XTAP_TAPCELL_ROW_16_201 VGND VPWR sky130_fd_sc_hd__tapvpwrvgnd_1
X_0822_ _0184_ _0185_ _0070_ VGND VGND VPWR VPWR _0186_ sky130_fd_sc_hd__a21o_1
XFILLER_9_66 VPWR VGND VPWR VGND sky130_ef_sc_hd__decap_12
XFILLER_50_3 VPWR VGND VPWR VGND sky130_ef_sc_hd__decap_12
X_0753_ _0123_ _0124_ VGND VGND VPWR VPWR _0125_ sky130_fd_sc_hd__and2_1
XTAP_TAPCELL_ROW_39_326 VGND VPWR sky130_fd_sc_hd__tapvpwrvgnd_1
X_1305_ _0629_ _0627_ _0630_ VGND VGND VPWR VPWR _0054_ sky130_fd_sc_hd__a21oi_1
X_1236_ _0558_ _0560_ net213 VGND VGND VPWR VPWR _0564_ sky130_fd_sc_hd__o21ai_1
XFILLER_29_309 VGND VGND VPWR VPWR sky130_fd_sc_hd__fill_2
XTAP_TAPCELL_ROW_47_370 VGND VPWR sky130_fd_sc_hd__tapvpwrvgnd_1
XPHY_EDGE_ROW_46_Left_99 VGND VGND VPWR VPWR sky130_fd_sc_hd__decap_3
X_1098_ net212 _0424_ _0422_ _0426_ VGND VGND VPWR VPWR _0428_ sky130_fd_sc_hd__o211ai_2
X_1167_ _0488_ _0489_ net176 _0479_ VGND VGND VPWR VPWR _0496_ sky130_fd_sc_hd__o211ai_4
XTAP_TAPCELL_ROW_30_281 VGND VPWR sky130_fd_sc_hd__tapvpwrvgnd_1
XFILLER_20_253 VPWR VGND VPWR VGND sky130_ef_sc_hd__decap_12
XTAP_TAPCELL_ROW_22_237 VGND VPWR sky130_fd_sc_hd__tapvpwrvgnd_1
XFILLER_18_97 VGND VGND VPWR VPWR sky130_fd_sc_hd__decap_8
XFILLER_34_41 VPWR VGND VPWR VGND sky130_ef_sc_hd__decap_12
XFILLER_7_213 VGND VGND VPWR VPWR sky130_fd_sc_hd__fill_1
XFILLER_11_242 VGND VGND VPWR VPWR sky130_fd_sc_hd__decap_4
XFILLER_7_268 VGND VGND VPWR VPWR sky130_fd_sc_hd__fill_1
XFILLER_38_139 VGND VGND VPWR VPWR sky130_fd_sc_hd__fill_1
X_1021_ _0344_ _0348_ _0337_ net144 VGND VGND VPWR VPWR _0352_ sky130_fd_sc_hd__o211ai_4
X_0805_ _0157_ _0159_ _0163_ _0164_ VGND VGND VPWR VPWR _0171_ sky130_fd_sc_hd__a22o_1
X_0736_ _0106_ net164 _0104_ VGND VGND VPWR VPWR _0110_ sky130_fd_sc_hd__a21oi_4
XFILLER_44_109 VPWR VGND VPWR VGND sky130_ef_sc_hd__decap_12
X_1219_ _0537_ _0538_ _0546_ VGND VGND VPWR VPWR _0547_ sky130_fd_sc_hd__o21bai_2
XFILLER_29_139 VGND VGND VPWR VPWR sky130_fd_sc_hd__fill_2
XFILLER_52_153 VPWR VGND VPWR VGND sky130_ef_sc_hd__decap_12
XTAP_TAPCELL_ROW_50_387 VGND VPWR sky130_fd_sc_hd__tapvpwrvgnd_1
XFILLER_45_73 VGND VGND VPWR VPWR sky130_fd_sc_hd__decap_8
XPHY_EDGE_ROW_7_Left_60 VGND VGND VPWR VPWR sky130_fd_sc_hd__decap_3
Xrebuffer17 _0182_ VGND VGND VPWR VPWR net149 sky130_fd_sc_hd__buf_6
Xrebuffer28 net161 VGND VGND VPWR VPWR net160 sky130_fd_sc_hd__dlygate4sd1_1
Xrebuffer39 _0103_ VGND VGND VPWR VPWR net171 sky130_fd_sc_hd__dlymetal6s2s_1
XFILLER_13_3 VPWR VGND VPWR VGND sky130_ef_sc_hd__decap_12
XFILLER_34_197 VGND VGND VPWR VPWR sky130_fd_sc_hd__decap_6
XFILLER_34_153 VPWR VGND VPWR VGND sky130_ef_sc_hd__decap_12
X_1004_ net89 net129 net224 net100 _0326_ VGND VGND VPWR VPWR _0335_ sky130_fd_sc_hd__a41o_1
Xrebuffer107 _0653_ VGND VGND VPWR VPWR net239 sky130_fd_sc_hd__buf_2
X_0719_ product_reg\[2\] net59 VGND VGND VPWR VPWR _0095_ sky130_fd_sc_hd__nand2_1
XFILLER_9_308 VGND VGND VPWR VPWR sky130_fd_sc_hd__decap_3
Xoutput42 net42 VGND VGND VPWR VPWR psum[14] sky130_fd_sc_hd__buf_2
Xoutput53 net53 VGND VGND VPWR VPWR psum[24] sky130_fd_sc_hd__buf_2
XPHY_EDGE_ROW_33_Left_86 VGND VGND VPWR VPWR sky130_fd_sc_hd__decap_3
Xoutput31 net31 VGND VGND VPWR VPWR b_out[2] sky130_fd_sc_hd__buf_2
Xoutput64 net64 VGND VGND VPWR VPWR psum[5] sky130_fd_sc_hd__buf_2
XFILLER_16_164 VGND VGND VPWR VPWR sky130_fd_sc_hd__decap_6
XFILLER_16_186 VGND VGND VPWR VPWR sky130_fd_sc_hd__decap_3
XFILLER_16_197 VGND VGND VPWR VPWR sky130_fd_sc_hd__fill_2
XTAP_TAPCELL_ROW_52_405 VGND VPWR sky130_fd_sc_hd__tapvpwrvgnd_1
XFILLER_22_189 VGND VGND VPWR VPWR sky130_fd_sc_hd__fill_1
XFILLER_45_215 VGND VGND VPWR VPWR sky130_fd_sc_hd__decap_8
Xclkbuf_3_6__f_clk clknet_0_clk VGND VGND VPWR VPWR clknet_3_6__leaf_clk sky130_fd_sc_hd__clkbuf_16
XFILLER_13_123 VGND VGND VPWR VPWR sky130_fd_sc_hd__decap_8
XFILLER_26_97 VPWR VGND VPWR VGND sky130_ef_sc_hd__decap_12
Xrebuffer8 _0427_ VGND VGND VPWR VPWR net140 sky130_fd_sc_hd__clkbuf_2
XFILLER_3_57 VPWR VGND VPWR VGND sky130_ef_sc_hd__decap_12
XTAP_TAPCELL_ROW_8_160 VGND VPWR sky130_fd_sc_hd__tapvpwrvgnd_1
XFILLER_36_248 VGND VGND VPWR VPWR sky130_fd_sc_hd__decap_4
XFILLER_36_226 VGND VGND VPWR VPWR sky130_fd_sc_hd__decap_4
X_0984_ _0288_ _0310_ _0311_ VGND VGND VPWR VPWR _0316_ sky130_fd_sc_hd__nand3_2
Xfanout117 net118 VGND VGND VPWR VPWR net117 sky130_fd_sc_hd__buf_6
X_1398_ clknet_3_6__leaf_clk _0024_ VGND VGND VPWR VPWR net52 sky130_fd_sc_hd__dfxtp_1
Xfanout106 net108 VGND VGND VPWR VPWR net106 sky130_fd_sc_hd__clkbuf_4
Xfanout128 net129 VGND VGND VPWR VPWR net128 sky130_fd_sc_hd__buf_12
XFILLER_50_251 VGND VGND VPWR VPWR sky130_fd_sc_hd__fill_1
XFILLER_35_281 VGND VGND VPWR VPWR sky130_fd_sc_hd__fill_1
XFILLER_6_108 VGND VGND VPWR VPWR sky130_fd_sc_hd__fill_1
XFILLER_12_88 VPWR VGND VPWR VGND sky130_ef_sc_hd__decap_12
Xhold193 _0685_ VGND VGND VPWR VPWR net325 sky130_fd_sc_hd__dlygate4sd3_1
Xhold182 reset VGND VGND VPWR VPWR net314 sky130_fd_sc_hd__dlygate4sd3_1
XFILLER_33_207 VPWR VGND VPWR VGND sky130_ef_sc_hd__decap_12
XTAP_TAPCELL_ROW_5_141 VGND VPWR sky130_fd_sc_hd__tapvpwrvgnd_1
XTAP_TAPCELL_ROW_28_265 VGND VPWR sky130_fd_sc_hd__tapvpwrvgnd_1
XFILLER_41_273 VGND VGND VPWR VPWR sky130_fd_sc_hd__fill_2
XFILLER_26_270 VPWR VGND VPWR VGND sky130_ef_sc_hd__decap_12
XFILLER_45_6 VPWR VGND VPWR VGND sky130_ef_sc_hd__decap_12
XTAP_TAPCELL_ROW_11_176 VGND VPWR sky130_fd_sc_hd__tapvpwrvgnd_1
X_1252_ net124 net121 net234 net92 VGND VGND VPWR VPWR _0579_ sky130_fd_sc_hd__nand4_4
X_1321_ _0618_ _0620_ _0616_ VGND VGND VPWR VPWR _0646_ sky130_fd_sc_hd__a21oi_1
XFILLER_17_281 VGND VGND VPWR VPWR sky130_fd_sc_hd__decap_3
XPHY_EDGE_ROW_20_Left_73 VGND VGND VPWR VPWR sky130_fd_sc_hd__decap_3
X_1183_ net260 _0510_ _0509_ VGND VGND VPWR VPWR _0512_ sky130_fd_sc_hd__o21ai_2
X_0967_ net103 net126 VGND VGND VPWR VPWR _0299_ sky130_fd_sc_hd__nand2_1
X_0898_ net330 net312 net109 net131 VGND VGND VPWR VPWR _0234_ sky130_fd_sc_hd__nand4_1
XPHY_EDGE_ROW_12_Right_12 VGND VGND VPWR VPWR sky130_fd_sc_hd__decap_3
XTAP_TAPCELL_ROW_2_122 VGND VPWR sky130_fd_sc_hd__tapvpwrvgnd_1
XPHY_EDGE_ROW_21_Right_21 VGND VGND VPWR VPWR sky130_fd_sc_hd__decap_3
XPHY_EDGE_ROW_30_Right_30 VGND VGND VPWR VPWR sky130_fd_sc_hd__decap_3
XFILLER_23_65 VGND VGND VPWR VPWR sky130_fd_sc_hd__fill_2
XTAP_TAPCELL_ROW_16_202 VGND VPWR sky130_fd_sc_hd__tapvpwrvgnd_1
X_0821_ net148 _0183_ _0179_ _0180_ VGND VGND VPWR VPWR _0185_ sky130_fd_sc_hd__o211ai_2
XFILLER_9_78 VPWR VGND VPWR VGND sky130_ef_sc_hd__decap_12
X_0752_ product_reg\[6\] net65 VGND VGND VPWR VPWR _0124_ sky130_fd_sc_hd__or2_1
XTAP_TAPCELL_ROW_39_327 VGND VPWR sky130_fd_sc_hd__tapvpwrvgnd_1
X_1304_ product_reg\[11\] net78 net84 VGND VGND VPWR VPWR _0630_ sky130_fd_sc_hd__o21ai_1
X_1235_ _0512_ _0515_ net233 VGND VGND VPWR VPWR _0563_ sky130_fd_sc_hd__o21a_1
X_1166_ _0477_ _0479_ _0486_ _0487_ VGND VGND VPWR VPWR _0495_ sky130_fd_sc_hd__o2bb2ai_2
XTAP_TAPCELL_ROW_47_371 VGND VPWR sky130_fd_sc_hd__tapvpwrvgnd_1
XFILLER_20_221 VPWR VGND VPWR VGND sky130_ef_sc_hd__decap_12
X_1097_ net143 _0354_ _0421_ _0420_ VGND VGND VPWR VPWR _0427_ sky130_fd_sc_hd__a22oi_4
XFILLER_20_265 VPWR VGND VPWR VGND sky130_ef_sc_hd__decap_12
XFILLER_20_287 VGND VGND VPWR VPWR sky130_fd_sc_hd__decap_3
XFILLER_47_107 VGND VGND VPWR VPWR sky130_fd_sc_hd__decap_4
XFILLER_47_129 VGND VGND VPWR VPWR sky130_fd_sc_hd__decap_3
XFILLER_34_53 VGND VGND VPWR VPWR sky130_fd_sc_hd__fill_2
XFILLER_7_225 VPWR VGND VPWR VGND sky130_ef_sc_hd__decap_12
XFILLER_11_276 VGND VGND VPWR VPWR sky130_fd_sc_hd__decap_4
X_1020_ net144 _0337_ _0349_ VGND VGND VPWR VPWR _0351_ sky130_fd_sc_hd__a21o_4
X_0804_ product_reg\[11\] net39 _0164_ _0163_ _0159_ VGND VGND VPWR VPWR _0170_ sky130_fd_sc_hd__o2111ai_4
X_0735_ net75 net375 net82 _0109_ VGND VGND VPWR VPWR _0004_ sky130_fd_sc_hd__o211a_1
X_1218_ _0544_ _0545_ VGND VGND VPWR VPWR _0546_ sky130_fd_sc_hd__nand2_1
X_1149_ net208 _0424_ _0475_ VGND VGND VPWR VPWR _0478_ sky130_fd_sc_hd__a21oi_2
XFILLER_52_165 VGND VGND VPWR VPWR sky130_fd_sc_hd__decap_3
XTAP_TAPCELL_ROW_50_388 VGND VPWR sky130_fd_sc_hd__tapvpwrvgnd_1
XPHY_EDGE_ROW_51_Left_104 VGND VGND VPWR VPWR sky130_fd_sc_hd__decap_3
XFILLER_3_272 VGND VGND VPWR VPWR sky130_fd_sc_hd__decap_4
Xrebuffer18 net149 VGND VGND VPWR VPWR net150 sky130_fd_sc_hd__buf_6
Xrebuffer29 net162 VGND VGND VPWR VPWR net161 sky130_fd_sc_hd__dlygate4sd1_1
X_1003_ net126 net102 _0328_ _0331_ VGND VGND VPWR VPWR _0334_ sky130_fd_sc_hd__a22o_1
XFILLER_34_165 VGND VGND VPWR VPWR sky130_fd_sc_hd__decap_8
X_0718_ net75 net277 net82 _0094_ VGND VGND VPWR VPWR _0002_ sky130_fd_sc_hd__o211a_1
XPHY_EDGE_ROW_6_Right_6 VGND VGND VPWR VPWR sky130_fd_sc_hd__decap_3
XFILLER_15_11 VGND VGND VPWR VPWR sky130_fd_sc_hd__fill_1
XFILLER_15_55 VGND VGND VPWR VPWR sky130_fd_sc_hd__fill_1
XFILLER_15_88 VGND VGND VPWR VPWR sky130_fd_sc_hd__decap_6
Xoutput43 net43 VGND VGND VPWR VPWR psum[15] sky130_fd_sc_hd__buf_2
Xoutput54 net54 VGND VGND VPWR VPWR psum[25] sky130_fd_sc_hd__buf_2
XFILLER_31_98 VGND VGND VPWR VPWR sky130_fd_sc_hd__fill_2
Xoutput32 net32 VGND VGND VPWR VPWR b_out[3] sky130_fd_sc_hd__buf_2
Xoutput21 net21 VGND VGND VPWR VPWR a_out[0] sky130_fd_sc_hd__buf_2
XFILLER_0_253 VPWR VGND VPWR VGND sky130_ef_sc_hd__decap_12
Xoutput65 net65 VGND VGND VPWR VPWR psum[6] sky130_fd_sc_hd__buf_2
XTAP_TAPCELL_ROW_52_406 VGND VPWR sky130_fd_sc_hd__tapvpwrvgnd_1
XFILLER_47_290 VPWR VGND VPWR VGND sky130_ef_sc_hd__decap_12
XFILLER_42_20 VGND VGND VPWR VPWR sky130_fd_sc_hd__fill_1
XFILLER_21_190 VGND VGND VPWR VPWR sky130_fd_sc_hd__decap_8
Xrebuffer9 _0498_ VGND VGND VPWR VPWR net141 sky130_fd_sc_hd__buf_6
XFILLER_3_69 VPWR VGND VPWR VGND sky130_ef_sc_hd__decap_12
X_0983_ _0308_ _0312_ _0313_ _0287_ VGND VGND VPWR VPWR _0315_ sky130_fd_sc_hd__o211ai_2
XFILLER_8_183 VPWR VGND VPWR VGND sky130_ef_sc_hd__decap_12
Xfanout129 net130 VGND VGND VPWR VPWR net129 sky130_fd_sc_hd__buf_12
Xfanout107 net108 VGND VGND VPWR VPWR net107 sky130_fd_sc_hd__clkbuf_4
Xfanout118 net14 VGND VGND VPWR VPWR net118 sky130_fd_sc_hd__buf_2
X_1397_ clknet_3_6__leaf_clk _0023_ VGND VGND VPWR VPWR net51 sky130_fd_sc_hd__dfxtp_1
XFILLER_50_285 VGND VGND VPWR VPWR sky130_fd_sc_hd__decap_6
XFILLER_10_127 VGND VGND VPWR VPWR sky130_fd_sc_hd__fill_1
XTAP_TAPCELL_ROW_5_142 VGND VPWR sky130_fd_sc_hd__tapvpwrvgnd_1
Xhold183 net18 VGND VGND VPWR VPWR net315 sky130_fd_sc_hd__dlygate4sd3_1
XFILLER_37_97 VGND VGND VPWR VPWR sky130_fd_sc_hd__decap_3
XFILLER_33_219 VGND VGND VPWR VPWR sky130_fd_sc_hd__decap_4
XFILLER_26_282 VGND VGND VPWR VPWR sky130_fd_sc_hd__decap_4
XTAP_TAPCELL_ROW_28_266 VGND VPWR sky130_fd_sc_hd__tapvpwrvgnd_1
X_1320_ _0643_ _0644_ VGND VGND VPWR VPWR _0645_ sky130_fd_sc_hd__nor2_1
XFILLER_5_120 VPWR VGND VPWR VGND sky130_ef_sc_hd__decap_12
X_1251_ net121 net95 net92 net124 VGND VGND VPWR VPWR _0578_ sky130_fd_sc_hd__a22o_2
X_1182_ _0435_ net232 _0507_ _0505_ _0508_ VGND VGND VPWR VPWR _0511_ sky130_fd_sc_hd__o2111ai_4
XFILLER_32_241 VGND VGND VPWR VPWR sky130_fd_sc_hd__fill_2
X_0897_ net372 net78 _0232_ net339 VGND VGND VPWR VPWR _0043_ sky130_fd_sc_hd__o22a_1
X_0966_ _0264_ _0265_ _0267_ VGND VGND VPWR VPWR _0298_ sky130_fd_sc_hd__o21a_1
XTAP_TAPCELL_ROW_2_123 VGND VPWR sky130_fd_sc_hd__tapvpwrvgnd_1
XFILLER_23_44 VGND VGND VPWR VPWR sky130_fd_sc_hd__fill_1
XFILLER_23_55 VGND VGND VPWR VPWR sky130_fd_sc_hd__fill_1
XFILLER_3_3 VPWR VGND VPWR VGND sky130_ef_sc_hd__decap_12
XFILLER_0_15 VPWR VGND VPWR VGND sky130_ef_sc_hd__decap_12
XFILLER_14_263 VPWR VGND VPWR VGND sky130_ef_sc_hd__decap_12
XTAP_TAPCELL_ROW_16_203 VGND VPWR sky130_fd_sc_hd__tapvpwrvgnd_1
X_0820_ _0179_ _0180_ net170 _0183_ VGND VGND VPWR VPWR _0184_ sky130_fd_sc_hd__a211o_1
X_0751_ product_reg\[6\] net65 VGND VGND VPWR VPWR _0123_ sky130_fd_sc_hd__nand2_1
XFILLER_36_3 VGND VGND VPWR VPWR sky130_fd_sc_hd__decap_8
X_1303_ _0603_ _0628_ _0085_ VGND VGND VPWR VPWR _0629_ sky130_fd_sc_hd__a21oi_1
XTAP_TAPCELL_ROW_47_372 VGND VPWR sky130_fd_sc_hd__tapvpwrvgnd_1
XTAP_TAPCELL_ROW_39_328 VGND VPWR sky130_fd_sc_hd__tapvpwrvgnd_1
XFILLER_37_300 VGND VGND VPWR VPWR sky130_fd_sc_hd__fill_1
X_1096_ _0337_ _0350_ _0338_ VGND VGND VPWR VPWR _0426_ sky130_fd_sc_hd__a21o_1
X_1234_ _0558_ _0560_ VGND VGND VPWR VPWR _0562_ sky130_fd_sc_hd__nor2_2
X_1165_ net133 net229 _0490_ VGND VGND VPWR VPWR _0494_ sky130_fd_sc_hd__a21oi_2
XFILLER_20_233 VGND VGND VPWR VPWR sky130_fd_sc_hd__decap_8
X_0949_ _0279_ _0280_ _0261_ VGND VGND VPWR VPWR _0282_ sky130_fd_sc_hd__a21o_1
XFILLER_20_277 VGND VGND VPWR VPWR sky130_fd_sc_hd__decap_3
XFILLER_7_237 VGND VGND VPWR VPWR sky130_fd_sc_hd__fill_1
XFILLER_11_222 VGND VGND VPWR VPWR sky130_fd_sc_hd__fill_2
XFILLER_46_141 VPWR VGND VPWR VGND sky130_ef_sc_hd__decap_12
XTAP_TAPCELL_ROW_36_309 VGND VPWR sky130_fd_sc_hd__tapvpwrvgnd_1
XTAP_TAPCELL_ROW_44_353 VGND VPWR sky130_fd_sc_hd__tapvpwrvgnd_1
X_0734_ _0107_ _0108_ net75 VGND VGND VPWR VPWR _0109_ sky130_fd_sc_hd__o21ai_1
X_0803_ product_reg\[9\] net68 _0168_ _0153_ VGND VGND VPWR VPWR _0169_ sky130_fd_sc_hd__o211ai_4
XFILLER_40_306 VGND VGND VPWR VPWR sky130_fd_sc_hd__fill_2
XFILLER_37_152 VPWR VGND VPWR VGND sky130_ef_sc_hd__decap_12
X_1217_ _0542_ _0543_ net108 net112 VGND VGND VPWR VPWR _0545_ sky130_fd_sc_hd__nand4_1
X_1148_ _0473_ _0472_ _0476_ VGND VGND VPWR VPWR _0477_ sky130_fd_sc_hd__o21ai_4
X_1079_ net124 net101 net120 net104 VGND VGND VPWR VPWR _0409_ sky130_fd_sc_hd__a22oi_4
XTAP_TAPCELL_ROW_50_389 VGND VPWR sky130_fd_sc_hd__tapvpwrvgnd_1
XFILLER_28_141 VPWR VGND VPWR VGND sky130_ef_sc_hd__decap_12
Xrebuffer19 net150 VGND VGND VPWR VPWR net151 sky130_fd_sc_hd__buf_6
X_1002_ _0327_ _0330_ _0326_ VGND VGND VPWR VPWR _0333_ sky130_fd_sc_hd__o21bai_2
XFILLER_22_306 VGND VGND VPWR VPWR sky130_fd_sc_hd__fill_2
X_0717_ _0092_ _0093_ net75 VGND VGND VPWR VPWR _0094_ sky130_fd_sc_hd__o21ai_1
XFILLER_31_55 VGND VGND VPWR VPWR sky130_fd_sc_hd__fill_1
Xoutput55 net55 VGND VGND VPWR VPWR psum[26] sky130_fd_sc_hd__buf_2
XFILLER_0_265 VPWR VGND VPWR VGND sky130_ef_sc_hd__decap_12
Xoutput33 net33 VGND VGND VPWR VPWR b_out[4] sky130_fd_sc_hd__buf_2
Xoutput22 net22 VGND VGND VPWR VPWR a_out[1] sky130_fd_sc_hd__buf_2
XFILLER_0_221 VGND VGND VPWR VPWR sky130_fd_sc_hd__decap_3
Xoutput66 net66 VGND VGND VPWR VPWR psum[7] sky130_fd_sc_hd__buf_2
Xoutput44 net44 VGND VGND VPWR VPWR psum[16] sky130_fd_sc_hd__buf_2
XFILLER_39_225 VPWR VGND VPWR VGND sky130_ef_sc_hd__decap_12
XTAP_TAPCELL_ROW_52_407 VGND VPWR sky130_fd_sc_hd__tapvpwrvgnd_1
XFILLER_22_147 VGND VGND VPWR VPWR sky130_fd_sc_hd__fill_1
XFILLER_10_309 VGND VGND VPWR VPWR sky130_fd_sc_hd__fill_2
XFILLER_22_169 VPWR VGND VPWR VGND sky130_ef_sc_hd__decap_12
XFILLER_38_291 VGND VGND VPWR VPWR sky130_fd_sc_hd__fill_2
XFILLER_9_129 VGND VGND VPWR VPWR sky130_fd_sc_hd__fill_1
XFILLER_13_103 VGND VGND VPWR VPWR sky130_fd_sc_hd__fill_1
XFILLER_13_169 VPWR VGND VPWR VGND sky130_ef_sc_hd__decap_12
XFILLER_3_15 VPWR VGND VPWR VGND sky130_ef_sc_hd__decap_12
XFILLER_8_195 VGND VGND VPWR VPWR sky130_fd_sc_hd__fill_1
X_0982_ net291 _0312_ _0287_ _0313_ VGND VGND VPWR VPWR _0314_ sky130_fd_sc_hd__o211a_1
Xfanout108 net3 VGND VGND VPWR VPWR net108 sky130_fd_sc_hd__clkbuf_4
Xfanout119 net122 VGND VGND VPWR VPWR net119 sky130_fd_sc_hd__buf_4
XFILLER_42_209 VPWR VGND VPWR VGND sky130_ef_sc_hd__decap_12
X_1396_ clknet_3_3__leaf_clk _0022_ VGND VGND VPWR VPWR net50 sky130_fd_sc_hd__dfxtp_1
XFILLER_10_139 VGND VGND VPWR VPWR sky130_fd_sc_hd__fill_1
XTAP_TAPCELL_ROW_5_143 VGND VPWR sky130_fd_sc_hd__tapvpwrvgnd_1
Xhold184 clear_acc VGND VGND VPWR VPWR net316 sky130_fd_sc_hd__dlygate4sd3_1
XFILLER_37_65 VGND VGND VPWR VPWR sky130_fd_sc_hd__fill_2
XTAP_TAPCELL_ROW_28_267 VGND VPWR sky130_fd_sc_hd__tapvpwrvgnd_1
XFILLER_5_165 VGND VGND VPWR VPWR sky130_fd_sc_hd__decap_3
XFILLER_5_132 VGND VGND VPWR VPWR sky130_fd_sc_hd__fill_1
X_1250_ net121 net217 net92 net124 VGND VGND VPWR VPWR _0577_ sky130_fd_sc_hd__a22oi_2
X_1181_ _0435_ net232 _0507_ _0508_ VGND VGND VPWR VPWR _0510_ sky130_fd_sc_hd__o211ai_2
X_0896_ net330 net131 net81 VGND VGND VPWR VPWR _0233_ sky130_fd_sc_hd__and3_1
X_0965_ _0264_ _0265_ _0267_ VGND VGND VPWR VPWR _0297_ sky130_fd_sc_hd__o21ai_1
XTAP_TAPCELL_ROW_2_124 VGND VPWR sky130_fd_sc_hd__tapvpwrvgnd_1
X_1379_ clknet_3_2__leaf_clk _0005_ VGND VGND VPWR VPWR net63 sky130_fd_sc_hd__dfxtp_1
XFILLER_46_301 VGND VGND VPWR VPWR sky130_fd_sc_hd__decap_3
XFILLER_0_27 VGND VGND VPWR VPWR sky130_fd_sc_hd__fill_1
XFILLER_0_49 VGND VGND VPWR VPWR sky130_fd_sc_hd__decap_3
XFILLER_9_47 VGND VGND VPWR VPWR sky130_fd_sc_hd__decap_3
XFILLER_14_275 VPWR VGND VPWR VGND sky130_ef_sc_hd__decap_12
XTAP_TAPCELL_ROW_16_204 VGND VPWR sky130_fd_sc_hd__tapvpwrvgnd_1
Xfanout90 net9 VGND VGND VPWR VPWR net90 sky130_fd_sc_hd__buf_8
X_0750_ _0070_ _0072_ net317 net315 _0122_ VGND VGND VPWR VPWR _0006_ sky130_fd_sc_hd__a2111oi_1
X_1302_ _0599_ _0626_ VGND VGND VPWR VPWR _0628_ sky130_fd_sc_hd__nor2_1
XFILLER_1_190 VPWR VGND VPWR VGND sky130_ef_sc_hd__decap_12
X_1233_ net142 _0555_ _0556_ _0557_ VGND VGND VPWR VPWR _0561_ sky130_fd_sc_hd__nand4_4
XTAP_TAPCELL_ROW_47_373 VGND VPWR sky130_fd_sc_hd__tapvpwrvgnd_1
XTAP_TAPCELL_ROW_39_329 VGND VPWR sky130_fd_sc_hd__tapvpwrvgnd_1
X_1164_ _0486_ _0487_ net136 _0475_ net134 VGND VGND VPWR VPWR _0493_ sky130_fd_sc_hd__o221ai_4
X_1095_ _0413_ _0415_ net215 net175 VGND VGND VPWR VPWR _0425_ sky130_fd_sc_hd__o211ai_1
X_0948_ _0261_ _0279_ _0280_ VGND VGND VPWR VPWR _0281_ sky130_fd_sc_hd__nand3_1
X_0879_ net369 net57 _0196_ _0222_ VGND VGND VPWR VPWR _0228_ sky130_fd_sc_hd__nand4_2
XFILLER_34_77 VGND VGND VPWR VPWR sky130_fd_sc_hd__decap_6
XFILLER_50_43 VPWR VGND VPWR VGND sky130_ef_sc_hd__decap_12
XFILLER_38_109 VPWR VGND VPWR VGND sky130_ef_sc_hd__decap_12
XFILLER_46_153 VPWR VGND VPWR VGND sky130_ef_sc_hd__decap_12
XTAP_TAPCELL_ROW_44_354 VGND VPWR sky130_fd_sc_hd__tapvpwrvgnd_1
X_0802_ _0151_ _0152_ _0157_ _0158_ VGND VGND VPWR VPWR _0168_ sky130_fd_sc_hd__and4_1
X_0733_ _0103_ _0105_ _0106_ VGND VGND VPWR VPWR _0108_ sky130_fd_sc_hd__and3_1
XFILLER_37_120 VGND VGND VPWR VPWR sky130_fd_sc_hd__decap_4
X_1216_ net107 net112 _0542_ _0543_ VGND VGND VPWR VPWR _0544_ sky130_fd_sc_hd__a22o_1
XFILLER_52_189 VGND VGND VPWR VPWR sky130_fd_sc_hd__decap_3
XFILLER_37_164 VGND VGND VPWR VPWR sky130_fd_sc_hd__decap_4
X_1147_ _0407_ _0419_ _0405_ VGND VGND VPWR VPWR _0476_ sky130_fd_sc_hd__a21oi_4
XFILLER_1_81 VPWR VGND VPWR VGND sky130_ef_sc_hd__decap_12
X_1078_ net107 net116 VGND VGND VPWR VPWR _0408_ sky130_fd_sc_hd__nand2_2
XFILLER_28_153 VPWR VGND VPWR VGND sky130_ef_sc_hd__decap_12
XFILLER_29_55 VGND VGND VPWR VPWR sky130_fd_sc_hd__fill_1
XFILLER_43_167 VGND VGND VPWR VPWR sky130_fd_sc_hd__fill_1
XFILLER_6_15 VPWR VGND VPWR VGND sky130_ef_sc_hd__decap_12
XFILLER_19_164 VGND VGND VPWR VPWR sky130_fd_sc_hd__decap_4
X_1001_ _0074_ _0076_ _0328_ _0331_ VGND VGND VPWR VPWR _0332_ sky130_fd_sc_hd__o211ai_4
X_0716_ _0090_ _0091_ product_reg\[0\] net37 VGND VGND VPWR VPWR _0093_ sky130_fd_sc_hd__and4_1
XFILLER_15_57 VPWR VGND VPWR VGND sky130_ef_sc_hd__decap_12
XFILLER_25_134 VGND VGND VPWR VPWR sky130_fd_sc_hd__fill_1
XFILLER_25_167 VGND VGND VPWR VPWR sky130_fd_sc_hd__fill_1
Xoutput34 net34 VGND VGND VPWR VPWR b_out[5] sky130_fd_sc_hd__buf_2
XFILLER_31_23 VGND VGND VPWR VPWR sky130_fd_sc_hd__fill_1
Xoutput23 net23 VGND VGND VPWR VPWR a_out[2] sky130_fd_sc_hd__buf_2
Xoutput56 net56 VGND VGND VPWR VPWR psum[27] sky130_fd_sc_hd__buf_2
XFILLER_0_277 VGND VGND VPWR VPWR sky130_fd_sc_hd__decap_3
XFILLER_0_233 VGND VGND VPWR VPWR sky130_fd_sc_hd__fill_1
Xoutput67 net67 VGND VGND VPWR VPWR psum[8] sky130_fd_sc_hd__buf_2
Xoutput45 net45 VGND VGND VPWR VPWR psum[17] sky130_fd_sc_hd__buf_2
XFILLER_11_3 VPWR VGND VPWR VGND sky130_ef_sc_hd__decap_12
XFILLER_30_181 VPWR VGND VPWR VGND sky130_ef_sc_hd__decap_12
XFILLER_5_303 VGND VGND VPWR VPWR sky130_fd_sc_hd__decap_8
XFILLER_3_27 VPWR VGND VPWR VGND sky130_ef_sc_hd__decap_12
XPHY_EDGE_ROW_48_Left_101 VGND VGND VPWR VPWR sky130_fd_sc_hd__decap_3
XFILLER_44_295 VGND VGND VPWR VPWR sky130_fd_sc_hd__decap_4
X_0981_ net305 _0294_ _0307_ _0308_ VGND VGND VPWR VPWR _0313_ sky130_fd_sc_hd__o2bb2ai_2
Xfanout109 net110 VGND VGND VPWR VPWR net109 sky130_fd_sc_hd__clkbuf_4
X_1395_ clknet_3_6__leaf_clk _0021_ VGND VGND VPWR VPWR net49 sky130_fd_sc_hd__dfxtp_1
XFILLER_27_207 VPWR VGND VPWR VGND sky130_ef_sc_hd__decap_12
Xhold185 net17 VGND VGND VPWR VPWR net317 sky130_fd_sc_hd__dlygate4sd3_1
XFILLER_37_44 VPWR VGND VPWR VGND sky130_ef_sc_hd__decap_12
XFILLER_18_229 VGND VGND VPWR VPWR sky130_fd_sc_hd__fill_1
XFILLER_37_77 VPWR VGND VPWR VGND sky130_ef_sc_hd__decap_12
XTAP_TAPCELL_ROW_28_268 VGND VPWR sky130_fd_sc_hd__tapvpwrvgnd_1
XFILLER_5_111 VGND VGND VPWR VPWR sky130_fd_sc_hd__fill_1
X_1180_ _0439_ _0366_ _0504_ _0506_ net181 VGND VGND VPWR VPWR _0509_ sky130_fd_sc_hd__o221ai_4
XFILLER_32_221 VPWR VGND VPWR VGND sky130_ef_sc_hd__decap_12
X_0964_ _0264_ _0267_ VGND VGND VPWR VPWR _0296_ sky130_fd_sc_hd__nand2_1
X_0895_ net20 net19 net79 VGND VGND VPWR VPWR _0232_ sky130_fd_sc_hd__a21oi_4
XFILLER_4_92 VGND VGND VPWR VPWR sky130_fd_sc_hd__decap_3
X_1378_ clknet_3_2__leaf_clk _0004_ VGND VGND VPWR VPWR net62 sky130_fd_sc_hd__dfxtp_1
XTAP_TAPCELL_ROW_2_125 VGND VPWR sky130_fd_sc_hd__tapvpwrvgnd_1
XTAP_TAPCELL_ROW_25_249 VGND VPWR sky130_fd_sc_hd__tapvpwrvgnd_1
XTAP_TAPCELL_ROW_33_293 VGND VPWR sky130_fd_sc_hd__tapvpwrvgnd_1
XFILLER_23_57 VGND VGND VPWR VPWR sky130_fd_sc_hd__decap_8
Xfanout91 net92 VGND VGND VPWR VPWR net91 sky130_fd_sc_hd__buf_12
Xfanout80 _0083_ VGND VGND VPWR VPWR net80 sky130_fd_sc_hd__buf_2
XFILLER_9_15 VPWR VGND VPWR VGND sky130_ef_sc_hd__decap_12
XFILLER_14_287 VGND VGND VPWR VPWR sky130_fd_sc_hd__decap_3
XFILLER_43_6 VGND VGND VPWR VPWR sky130_fd_sc_hd__decap_8
XPHY_EDGE_ROW_24_Left_77 VGND VGND VPWR VPWR sky130_fd_sc_hd__decap_3
X_1301_ _0599_ net157 _0626_ VGND VGND VPWR VPWR _0627_ sky130_fd_sc_hd__o21ai_1
X_1232_ _0556_ _0555_ net142 _0557_ VGND VGND VPWR VPWR _0560_ sky130_fd_sc_hd__and4_1
XFILLER_52_305 VGND VGND VPWR VPWR sky130_fd_sc_hd__decap_3
XTAP_TAPCELL_ROW_47_374 VGND VPWR sky130_fd_sc_hd__tapvpwrvgnd_1
X_1163_ _0486_ _0487_ _0476_ _0475_ VGND VGND VPWR VPWR _0492_ sky130_fd_sc_hd__o22ai_2
X_1094_ _0413_ _0415_ net175 VGND VGND VPWR VPWR _0424_ sky130_fd_sc_hd__o21ai_1
X_0947_ _0272_ _0273_ _0277_ VGND VGND VPWR VPWR _0280_ sky130_fd_sc_hd__nand3_1
X_0878_ _0196_ net57 net58 _0222_ VGND VGND VPWR VPWR _0227_ sky130_fd_sc_hd__and4_1
XFILLER_11_246 VGND VGND VPWR VPWR sky130_fd_sc_hd__fill_1
XFILLER_50_55 VPWR VGND VPWR VGND sky130_ef_sc_hd__decap_12
Xclkload0 clknet_3_0__leaf_clk VGND VGND VPWR VPWR clkload0/X sky130_fd_sc_hd__clkbuf_8
XTAP_TAPCELL_ROW_21_230 VGND VPWR sky130_fd_sc_hd__tapvpwrvgnd_1
XFILLER_46_165 VPWR VGND VPWR VGND sky130_ef_sc_hd__decap_12
XFILLER_46_121 VPWR VGND VPWR VGND sky130_ef_sc_hd__decap_12
XTAP_TAPCELL_ROW_44_355 VGND VPWR sky130_fd_sc_hd__tapvpwrvgnd_1
X_0801_ product_reg\[11\] net39 _0166_ VGND VGND VPWR VPWR _0167_ sky130_fd_sc_hd__a21oi_1
X_0732_ _0105_ _0106_ net158 VGND VGND VPWR VPWR _0107_ sky130_fd_sc_hd__a21oi_1
X_1215_ _0073_ _0079_ _0451_ _0452_ _0454_ VGND VGND VPWR VPWR _0543_ sky130_fd_sc_hd__o221ai_4
X_1146_ net228 _0471_ _0474_ VGND VGND VPWR VPWR _0475_ sky130_fd_sc_hd__o21ai_4
XFILLER_52_146 VGND VGND VPWR VPWR sky130_fd_sc_hd__decap_4
XFILLER_52_113 VGND VGND VPWR VPWR sky130_fd_sc_hd__fill_2
X_1077_ _0400_ _0394_ _0401_ VGND VGND VPWR VPWR _0407_ sky130_fd_sc_hd__nand3_4
XFILLER_1_93 VPWR VGND VPWR VGND sky130_ef_sc_hd__decap_12
XFILLER_4_209 VGND VGND VPWR VPWR sky130_fd_sc_hd__decap_6
XFILLER_43_146 VGND VGND VPWR VPWR sky130_fd_sc_hd__decap_6
XFILLER_43_113 VGND VGND VPWR VPWR sky130_fd_sc_hd__decap_6
XFILLER_28_165 VGND VGND VPWR VPWR sky130_fd_sc_hd__decap_4
XFILLER_6_27 VGND VGND VPWR VPWR sky130_fd_sc_hd__fill_1
XFILLER_3_297 VPWR VGND VPWR VGND sky130_ef_sc_hd__decap_12
XFILLER_19_143 VPWR VGND VPWR VGND sky130_ef_sc_hd__decap_12
X_1000_ net90 net309 net223 net100 VGND VGND VPWR VPWR _0331_ sky130_fd_sc_hd__nand4_4
X_0715_ product_reg\[0\] net37 _0090_ _0091_ VGND VGND VPWR VPWR _0092_ sky130_fd_sc_hd__a22oi_1
XPHY_EDGE_ROW_27_Left_80 VGND VGND VPWR VPWR sky130_fd_sc_hd__decap_3
X_1129_ _0452_ _0457_ VGND VGND VPWR VPWR _0458_ sky130_fd_sc_hd__nor2_2
XPHY_EDGE_ROW_11_Left_64 VGND VGND VPWR VPWR sky130_fd_sc_hd__decap_3
XFILLER_40_149 VGND VGND VPWR VPWR sky130_fd_sc_hd__decap_3
XFILLER_40_138 VGND VGND VPWR VPWR sky130_fd_sc_hd__fill_2
XFILLER_15_47 VGND VGND VPWR VPWR sky130_fd_sc_hd__decap_8
XFILLER_15_69 VGND VGND VPWR VPWR sky130_fd_sc_hd__decap_4
Xoutput35 net35 VGND VGND VPWR VPWR b_out[6] sky130_fd_sc_hd__buf_2
Xoutput57 net57 VGND VGND VPWR VPWR psum[28] sky130_fd_sc_hd__buf_2
Xoutput24 net24 VGND VGND VPWR VPWR a_out[3] sky130_fd_sc_hd__buf_2
Xoutput46 net46 VGND VGND VPWR VPWR psum[18] sky130_fd_sc_hd__buf_2
XFILLER_48_249 VGND VGND VPWR VPWR sky130_fd_sc_hd__decap_3
XFILLER_48_205 VPWR VGND VPWR VGND sky130_ef_sc_hd__decap_12
XFILLER_0_245 VGND VGND VPWR VPWR sky130_fd_sc_hd__decap_3
Xoutput68 net68 VGND VGND VPWR VPWR psum[9] sky130_fd_sc_hd__buf_2
XPHY_EDGE_ROW_19_Right_19 VGND VGND VPWR VPWR sky130_fd_sc_hd__decap_3
Xclkbuf_3_1__f_clk clknet_0_clk VGND VGND VPWR VPWR clknet_3_1__leaf_clk sky130_fd_sc_hd__clkbuf_16
XPHY_EDGE_ROW_28_Right_28 VGND VGND VPWR VPWR sky130_fd_sc_hd__decap_3
XPHY_EDGE_ROW_37_Right_37 VGND VGND VPWR VPWR sky130_fd_sc_hd__decap_3
XFILLER_22_116 VGND VGND VPWR VPWR sky130_fd_sc_hd__fill_1
XFILLER_22_127 VGND VGND VPWR VPWR sky130_fd_sc_hd__decap_4
XPHY_EDGE_ROW_46_Right_46 VGND VGND VPWR VPWR sky130_fd_sc_hd__decap_3
XFILLER_30_193 VGND VGND VPWR VPWR sky130_fd_sc_hd__decap_3
XFILLER_26_46 VGND VGND VPWR VPWR sky130_fd_sc_hd__fill_2
XFILLER_3_39 VPWR VGND VPWR VGND sky130_ef_sc_hd__decap_12
XFILLER_44_230 VGND VGND VPWR VPWR sky130_fd_sc_hd__fill_1
X_0980_ _0306_ _0298_ _0295_ VGND VGND VPWR VPWR _0312_ sky130_fd_sc_hd__a21o_1
XFILLER_12_160 VPWR VGND VPWR VGND sky130_ef_sc_hd__decap_12
XTAP_TAPCELL_ROW_14_188 VGND VPWR sky130_fd_sc_hd__tapvpwrvgnd_1
XFILLER_8_197 VGND VGND VPWR VPWR sky130_fd_sc_hd__decap_6
XFILLER_12_193 VGND VGND VPWR VPWR sky130_fd_sc_hd__decap_3
X_1394_ clknet_3_3__leaf_clk _0020_ VGND VGND VPWR VPWR net47 sky130_fd_sc_hd__dfxtp_1
XFILLER_27_219 VGND VGND VPWR VPWR sky130_fd_sc_hd__decap_4
XFILLER_12_15 VPWR VGND VPWR VGND sky130_ef_sc_hd__decap_12
XFILLER_12_48 VGND VGND VPWR VPWR sky130_fd_sc_hd__fill_2
Xhold186 v_b_in VGND VGND VPWR VPWR net318 sky130_fd_sc_hd__dlygate4sd3_1
Xhold197 _0258_ VGND VGND VPWR VPWR net329 sky130_fd_sc_hd__dlygate4sd3_1
XFILLER_37_89 VGND VGND VPWR VPWR sky130_fd_sc_hd__decap_8
XFILLER_37_23 VGND VGND VPWR VPWR sky130_fd_sc_hd__fill_2
XFILLER_26_241 VGND VGND VPWR VPWR sky130_fd_sc_hd__fill_2
XTAP_TAPCELL_ROW_28_269 VGND VPWR sky130_fd_sc_hd__tapvpwrvgnd_1
XFILLER_5_189 VGND VGND VPWR VPWR sky130_fd_sc_hd__fill_2
XFILLER_32_200 VGND VGND VPWR VPWR sky130_fd_sc_hd__fill_1
X_0894_ net356 net79 VGND VGND VPWR VPWR _0042_ sky130_fd_sc_hd__nor2_1
XFILLER_32_233 VGND VGND VPWR VPWR sky130_fd_sc_hd__decap_8
X_0963_ _0293_ _0294_ VGND VGND VPWR VPWR _0295_ sky130_fd_sc_hd__nand2_4
X_1377_ clknet_3_2__leaf_clk _0003_ VGND VGND VPWR VPWR net59 sky130_fd_sc_hd__dfxtp_1
XTAP_TAPCELL_ROW_2_126 VGND VPWR sky130_fd_sc_hd__tapvpwrvgnd_1
XTAP_TAPCELL_ROW_33_294 VGND VPWR sky130_fd_sc_hd__tapvpwrvgnd_1
XFILLER_0_29 VPWR VGND VPWR VGND sky130_ef_sc_hd__decap_12
XFILLER_14_211 VGND VGND VPWR VPWR sky130_fd_sc_hd__decap_8
Xfanout92 net93 VGND VGND VPWR VPWR net92 sky130_fd_sc_hd__buf_6
XFILLER_9_27 VPWR VGND VPWR VGND sky130_ef_sc_hd__decap_12
Xfanout81 net86 VGND VGND VPWR VPWR net81 sky130_fd_sc_hd__clkbuf_2
XFILLER_13_91 VPWR VGND VPWR VGND sky130_ef_sc_hd__decap_12
XFILLER_49_185 VGND VGND VPWR VPWR sky130_fd_sc_hd__fill_2
X_1300_ _0624_ _0625_ VGND VGND VPWR VPWR _0626_ sky130_fd_sc_hd__nand2b_1
X_1162_ _0477_ _0479_ _0488_ _0489_ VGND VGND VPWR VPWR _0491_ sky130_fd_sc_hd__o2bb2ai_2
X_1231_ _0556_ _0555_ _0557_ net142 VGND VGND VPWR VPWR _0559_ sky130_fd_sc_hd__a22o_4
X_1093_ _0414_ _0416_ _0404_ _0394_ VGND VGND VPWR VPWR _0423_ sky130_fd_sc_hd__a22oi_2
X_0877_ net57 _0224_ net85 _0225_ VGND VGND VPWR VPWR _0029_ sky130_fd_sc_hd__o211a_1
X_0946_ _0273_ _0272_ _0277_ VGND VGND VPWR VPWR _0279_ sky130_fd_sc_hd__a21o_1
XFILLER_9_270 VGND VGND VPWR VPWR sky130_fd_sc_hd__decap_8
X_1429_ clknet_3_4__leaf_clk _0055_ VGND VGND VPWR VPWR product_reg\[12\] sky130_fd_sc_hd__dfxtp_1
XTAP_TAPCELL_ROW_38_320 VGND VPWR sky130_fd_sc_hd__tapvpwrvgnd_1
XPHY_EDGE_ROW_41_Left_94 VGND VGND VPWR VPWR sky130_fd_sc_hd__decap_3
XFILLER_7_218 VGND VGND VPWR VPWR sky130_fd_sc_hd__decap_6
XFILLER_7_207 VGND VGND VPWR VPWR sky130_fd_sc_hd__decap_6
Xclkload1 clknet_3_1__leaf_clk VGND VGND VPWR VPWR clkload1/Y sky130_fd_sc_hd__clkinvlp_4
XFILLER_11_225 VPWR VGND VPWR VGND sky130_ef_sc_hd__decap_12
XTAP_TAPCELL_ROW_21_231 VGND VPWR sky130_fd_sc_hd__tapvpwrvgnd_1
XFILLER_50_67 VGND VGND VPWR VPWR sky130_fd_sc_hd__decap_8
XFILLER_1_3 VPWR VGND VPWR VGND sky130_ef_sc_hd__decap_12
XFILLER_46_133 VGND VGND VPWR VPWR sky130_fd_sc_hd__decap_6
XFILLER_46_177 VGND VGND VPWR VPWR sky130_fd_sc_hd__fill_1
XTAP_TAPCELL_ROW_44_356 VGND VPWR sky130_fd_sc_hd__tapvpwrvgnd_1
X_0731_ product_reg\[3\] net62 VGND VGND VPWR VPWR _0106_ sky130_fd_sc_hd__or2_1
X_0800_ _0157_ net38 product_reg\[10\] VGND VGND VPWR VPWR _0166_ sky130_fd_sc_hd__and3_1
XFILLER_34_3 VGND VGND VPWR VPWR sky130_fd_sc_hd__decap_6
X_1145_ _0455_ _0458_ _0467_ _0469_ VGND VGND VPWR VPWR _0474_ sky130_fd_sc_hd__o22ai_4
X_1214_ _0540_ net115 net105 _0453_ VGND VGND VPWR VPWR _0542_ sky130_fd_sc_hd__nand4_1
XFILLER_52_169 VGND VGND VPWR VPWR sky130_fd_sc_hd__fill_2
XFILLER_40_309 VGND VGND VPWR VPWR sky130_fd_sc_hd__fill_2
X_1076_ net155 _0403_ _0393_ _0402_ VGND VGND VPWR VPWR _0406_ sky130_fd_sc_hd__o211ai_4
X_0929_ _0246_ _0248_ _0247_ VGND VGND VPWR VPWR _0262_ sky130_fd_sc_hd__o21ai_2
XFILLER_29_57 VGND VGND VPWR VPWR sky130_fd_sc_hd__decap_6
XFILLER_28_133 VGND VGND VPWR VPWR sky130_fd_sc_hd__decap_6
XTAP_TAPCELL_ROW_41_337 VGND VPWR sky130_fd_sc_hd__tapvpwrvgnd_1
XFILLER_3_210 VGND VGND VPWR VPWR sky130_fd_sc_hd__decap_4
XFILLER_19_155 VGND VGND VPWR VPWR sky130_fd_sc_hd__fill_1
XFILLER_22_309 VGND VGND VPWR VPWR sky130_fd_sc_hd__fill_2
X_0714_ product_reg\[1\] net278 VGND VGND VPWR VPWR _0091_ sky130_fd_sc_hd__nand2_1
X_1128_ _0454_ net117 net104 VGND VGND VPWR VPWR _0457_ sky130_fd_sc_hd__nand3_2
X_1059_ _0385_ _0386_ net132 net112 VGND VGND VPWR VPWR _0389_ sky130_fd_sc_hd__and4_1
XFILLER_25_169 VGND VGND VPWR VPWR sky130_fd_sc_hd__fill_1
Xoutput69 net69 VGND VGND VPWR VPWR v_a_out sky130_fd_sc_hd__buf_2
Xoutput36 net36 VGND VGND VPWR VPWR b_out[7] sky130_fd_sc_hd__buf_2
Xoutput25 net25 VGND VGND VPWR VPWR a_out[4] sky130_fd_sc_hd__buf_2
Xoutput58 net58 VGND VGND VPWR VPWR psum[29] sky130_fd_sc_hd__buf_2
Xoutput47 net47 VGND VGND VPWR VPWR psum[19] sky130_fd_sc_hd__buf_2
XFILLER_48_217 VPWR VGND VPWR VGND sky130_ef_sc_hd__decap_12
XFILLER_31_117 VGND VGND VPWR VPWR sky130_fd_sc_hd__fill_2
XFILLER_16_125 VGND VGND VPWR VPWR sky130_fd_sc_hd__fill_1
XFILLER_47_261 VGND VGND VPWR VPWR sky130_fd_sc_hd__decap_6
XFILLER_15_191 VPWR VGND VPWR VGND sky130_ef_sc_hd__decap_12
XFILLER_38_283 VGND VGND VPWR VPWR sky130_fd_sc_hd__decap_8
XFILLER_26_25 VGND VGND VPWR VPWR sky130_fd_sc_hd__decap_3
XFILLER_26_58 VPWR VGND VPWR VGND sky130_ef_sc_hd__decap_12
XFILLER_8_110 VPWR VGND VPWR VGND sky130_ef_sc_hd__decap_12
XFILLER_12_172 VGND VGND VPWR VPWR sky130_fd_sc_hd__decap_4
XTAP_TAPCELL_ROW_14_189 VGND VPWR sky130_fd_sc_hd__tapvpwrvgnd_1
X_1393_ clknet_3_3__leaf_clk _0019_ VGND VGND VPWR VPWR net46 sky130_fd_sc_hd__dfxtp_1
XFILLER_50_245 VGND VGND VPWR VPWR sky130_fd_sc_hd__decap_6
XFILLER_12_27 VGND VGND VPWR VPWR sky130_fd_sc_hd__fill_1
Xhold187 net20 VGND VGND VPWR VPWR net319 sky130_fd_sc_hd__dlygate4sd3_1
Xhold198 net89 VGND VGND VPWR VPWR net330 sky130_fd_sc_hd__dlygate4sd3_1
XFILLER_37_57 VGND VGND VPWR VPWR sky130_fd_sc_hd__decap_8
XFILLER_37_35 VGND VGND VPWR VPWR sky130_fd_sc_hd__fill_2
XFILLER_37_13 VGND VGND VPWR VPWR sky130_fd_sc_hd__fill_2
XFILLER_18_209 VGND VGND VPWR VPWR sky130_fd_sc_hd__decap_4
XFILLER_26_286 VGND VGND VPWR VPWR sky130_fd_sc_hd__fill_1
XFILLER_5_157 VGND VGND VPWR VPWR sky130_fd_sc_hd__decap_8
XFILLER_17_275 VGND VGND VPWR VPWR sky130_fd_sc_hd__fill_1
X_0962_ _0292_ net116 net131 _0290_ VGND VGND VPWR VPWR _0294_ sky130_fd_sc_hd__nand4_2
X_0893_ net168 net81 VGND VGND VPWR VPWR _0041_ sky130_fd_sc_hd__and2_1
XTAP_TAPCELL_ROW_10_170 VGND VPWR sky130_fd_sc_hd__tapvpwrvgnd_1
XTAP_TAPCELL_ROW_2_127 VGND VPWR sky130_fd_sc_hd__tapvpwrvgnd_1
X_1376_ clknet_3_2__leaf_clk _0002_ VGND VGND VPWR VPWR net48 sky130_fd_sc_hd__dfxtp_4
XTAP_TAPCELL_ROW_33_295 VGND VPWR sky130_fd_sc_hd__tapvpwrvgnd_1
XFILLER_23_267 VPWR VGND VPWR VGND sky130_ef_sc_hd__decap_12
Xfanout93 net8 VGND VGND VPWR VPWR net93 sky130_fd_sc_hd__buf_4
XFILLER_9_39 VGND VGND VPWR VPWR sky130_fd_sc_hd__decap_8
Xfanout82 net86 VGND VGND VPWR VPWR net82 sky130_fd_sc_hd__clkbuf_4
Xfanout71 net72 VGND VGND VPWR VPWR net71 sky130_fd_sc_hd__buf_8
X_1092_ _0406_ _0407_ _0417_ _0418_ VGND VGND VPWR VPWR _0422_ sky130_fd_sc_hd__o2bb2ai_1
X_1161_ _0486_ _0487_ VGND VGND VPWR VPWR _0490_ sky130_fd_sc_hd__nor2_1
X_1230_ _0555_ _0556_ _0557_ net142 VGND VGND VPWR VPWR _0558_ sky130_fd_sc_hd__a22oi_2
X_0876_ _0195_ net150 net57 _0193_ _0223_ VGND VGND VPWR VPWR _0226_ sky130_fd_sc_hd__o2111a_1
X_0945_ _0275_ _0276_ VGND VGND VPWR VPWR _0278_ sky130_fd_sc_hd__or2_1
XTAP_TAPCELL_ROW_30_276 VGND VPWR sky130_fd_sc_hd__tapvpwrvgnd_1
X_1428_ clknet_3_4__leaf_clk _0054_ VGND VGND VPWR VPWR product_reg\[11\] sky130_fd_sc_hd__dfxtp_1
XFILLER_18_26 VGND VGND VPWR VPWR sky130_fd_sc_hd__fill_2
XTAP_TAPCELL_ROW_38_321 VGND VPWR sky130_fd_sc_hd__tapvpwrvgnd_1
X_1359_ _0673_ _0674_ _0681_ VGND VGND VPWR VPWR _0682_ sky130_fd_sc_hd__nand3_1
Xclkload2 clknet_3_4__leaf_clk VGND VGND VPWR VPWR clkload2/Y sky130_fd_sc_hd__clkinv_4
XFILLER_11_237 VGND VGND VPWR VPWR sky130_fd_sc_hd__fill_2
XTAP_TAPCELL_ROW_44_357 VGND VPWR sky130_fd_sc_hd__tapvpwrvgnd_1
X_0730_ product_reg\[3\] net62 VGND VGND VPWR VPWR _0105_ sky130_fd_sc_hd__nand2_1
X_1213_ _0540_ net104 _0453_ net114 VGND VGND VPWR VPWR _0541_ sky130_fd_sc_hd__and4_1
XFILLER_27_3 VGND VGND VPWR VPWR sky130_fd_sc_hd__decap_6
XFILLER_52_126 VPWR VGND VPWR VGND sky130_ef_sc_hd__decap_12
X_1144_ _0455_ _0458_ _0468_ _0470_ VGND VGND VPWR VPWR _0473_ sky130_fd_sc_hd__a2bb2oi_2
X_1075_ net147 _0403_ _0402_ _0393_ VGND VGND VPWR VPWR _0405_ sky130_fd_sc_hd__o211a_4
XFILLER_1_51 VGND VGND VPWR VPWR sky130_fd_sc_hd__decap_4
X_0859_ net52 net280 net74 net53 VGND VGND VPWR VPWR _0213_ sky130_fd_sc_hd__a31o_1
X_0928_ _0245_ _0253_ _0255_ VGND VGND VPWR VPWR _0261_ sky130_fd_sc_hd__o21ai_1
XFILLER_29_47 VGND VGND VPWR VPWR sky130_fd_sc_hd__decap_8
XFILLER_51_181 VPWR VGND VPWR VGND sky130_ef_sc_hd__decap_12
XFILLER_45_57 VGND VGND VPWR VPWR sky130_fd_sc_hd__fill_1
XTAP_TAPCELL_ROW_41_338 VGND VPWR sky130_fd_sc_hd__tapvpwrvgnd_1
XFILLER_16_307 VGND VGND VPWR VPWR sky130_fd_sc_hd__fill_1
XFILLER_6_29 VPWR VGND VPWR VGND sky130_ef_sc_hd__decap_12
XFILLER_19_101 VGND VGND VPWR VPWR sky130_fd_sc_hd__decap_3
XFILLER_42_192 VGND VGND VPWR VPWR sky130_fd_sc_hd__decap_4
X_0713_ product_reg\[1\] net276 VGND VGND VPWR VPWR _0090_ sky130_fd_sc_hd__or2_1
X_1127_ _0453_ _0454_ _0073_ _0078_ VGND VGND VPWR VPWR _0456_ sky130_fd_sc_hd__o2bb2ai_2
X_1058_ _0385_ _0386_ _0075_ net87 VGND VGND VPWR VPWR _0388_ sky130_fd_sc_hd__o2bb2a_2
XFILLER_31_37 VPWR VGND VPWR VGND sky130_ef_sc_hd__decap_12
Xoutput26 net26 VGND VGND VPWR VPWR a_out[5] sky130_fd_sc_hd__buf_2
XPHY_EDGE_ROW_1_Right_1 VGND VGND VPWR VPWR sky130_fd_sc_hd__decap_3
XFILLER_0_225 VGND VGND VPWR VPWR sky130_fd_sc_hd__decap_8
Xoutput48 net278 VGND VGND VPWR VPWR psum[1] sky130_fd_sc_hd__buf_2
Xoutput37 net37 VGND VGND VPWR VPWR psum[0] sky130_fd_sc_hd__buf_2
Xoutput59 net59 VGND VGND VPWR VPWR psum[2] sky130_fd_sc_hd__buf_2
XFILLER_48_229 VPWR VGND VPWR VGND sky130_ef_sc_hd__decap_12
XFILLER_24_170 VGND VGND VPWR VPWR sky130_fd_sc_hd__decap_8
XFILLER_21_70 VGND VGND VPWR VPWR sky130_fd_sc_hd__fill_2
XTAP_TAPCELL_ROW_8_155 VGND VPWR sky130_fd_sc_hd__tapvpwrvgnd_1
XFILLER_8_122 VGND VGND VPWR VPWR sky130_fd_sc_hd__decap_6
X_1392_ clknet_3_3__leaf_clk _0018_ VGND VGND VPWR VPWR net45 sky130_fd_sc_hd__dfxtp_1
XFILLER_2_309 VGND VGND VPWR VPWR sky130_fd_sc_hd__fill_2
Xhold188 v_a_in VGND VGND VPWR VPWR net320 sky130_fd_sc_hd__dlygate4sd3_1
Xhold199 _0234_ VGND VGND VPWR VPWR net331 sky130_fd_sc_hd__dlygate4sd3_1
XFILLER_5_169 VPWR VGND VPWR VGND sky130_ef_sc_hd__decap_12
XTAP_TAPCELL_ROW_19_216 VGND VPWR sky130_fd_sc_hd__tapvpwrvgnd_1
XFILLER_32_268 VGND VGND VPWR VPWR sky130_fd_sc_hd__decap_8
X_0961_ _0075_ _0078_ _0289_ _0291_ VGND VGND VPWR VPWR _0293_ sky130_fd_sc_hd__o22ai_4
XFILLER_17_232 VGND VGND VPWR VPWR sky130_fd_sc_hd__decap_8
XTAP_TAPCELL_ROW_27_260 VGND VPWR sky130_fd_sc_hd__tapvpwrvgnd_1
XFILLER_27_91 VGND VGND VPWR VPWR sky130_fd_sc_hd__decap_8
X_0892_ net346 net79 VGND VGND VPWR VPWR _0040_ sky130_fd_sc_hd__nor2_1
XTAP_TAPCELL_ROW_10_171 VGND VPWR sky130_fd_sc_hd__tapvpwrvgnd_1
X_1375_ clknet_3_1__leaf_clk _0001_ VGND VGND VPWR VPWR net37 sky130_fd_sc_hd__dfxtp_2
XTAP_TAPCELL_ROW_33_296 VGND VPWR sky130_fd_sc_hd__tapvpwrvgnd_1
XFILLER_23_49 VGND VGND VPWR VPWR sky130_fd_sc_hd__decap_6
XFILLER_23_279 VGND VGND VPWR VPWR sky130_fd_sc_hd__fill_1
XFILLER_2_139 VGND VGND VPWR VPWR sky130_fd_sc_hd__fill_1
Xfanout72 _0197_ VGND VGND VPWR VPWR net72 sky130_fd_sc_hd__buf_6
Xfanout94 net95 VGND VGND VPWR VPWR net94 sky130_fd_sc_hd__buf_12
Xfanout83 net86 VGND VGND VPWR VPWR net83 sky130_fd_sc_hd__dlymetal6s2s_1
Xclkbuf_3_7__f_clk clknet_0_clk VGND VGND VPWR VPWR clknet_3_7__leaf_clk sky130_fd_sc_hd__clkbuf_16
X_1160_ _0483_ _0484_ _0480_ VGND VGND VPWR VPWR _0489_ sky130_fd_sc_hd__a21oi_2
X_1091_ _0417_ _0418_ net214 _0407_ VGND VGND VPWR VPWR _0421_ sky130_fd_sc_hd__o211ai_4
X_0944_ _0275_ _0276_ VGND VGND VPWR VPWR _0277_ sky130_fd_sc_hd__nor2_1
XFILLER_20_249 VGND VGND VPWR VPWR sky130_fd_sc_hd__decap_3
X_0875_ _0195_ net151 net57 _0193_ _0222_ VGND VGND VPWR VPWR _0225_ sky130_fd_sc_hd__o2111ai_2
XTAP_TAPCELL_ROW_30_277 VGND VPWR sky130_fd_sc_hd__tapvpwrvgnd_1
X_1358_ _0679_ net73 VGND VGND VPWR VPWR _0681_ sky130_fd_sc_hd__nor2_1
X_1427_ clknet_3_4__leaf_clk _0053_ VGND VGND VPWR VPWR product_reg\[10\] sky130_fd_sc_hd__dfxtp_1
X_1289_ _0608_ _0609_ _0611_ _0612_ VGND VGND VPWR VPWR _0615_ sky130_fd_sc_hd__and4_1
XFILLER_43_308 VGND VGND VPWR VPWR sky130_fd_sc_hd__decap_3
XTAP_TAPCELL_ROW_38_322 VGND VPWR sky130_fd_sc_hd__tapvpwrvgnd_1
Xclkload3 clknet_3_5__leaf_clk VGND VGND VPWR VPWR clkload3/Y sky130_fd_sc_hd__bufinv_16
XFILLER_46_102 VGND VGND VPWR VPWR sky130_fd_sc_hd__fill_2
XTAP_TAPCELL_ROW_44_358 VGND VPWR sky130_fd_sc_hd__tapvpwrvgnd_1
XFILLER_41_6 VGND VGND VPWR VPWR sky130_fd_sc_hd__fill_2
XFILLER_6_253 VPWR VGND VPWR VGND sky130_ef_sc_hd__decap_12
X_1212_ _0451_ _0454_ VGND VGND VPWR VPWR _0540_ sky130_fd_sc_hd__nand2_1
XFILLER_52_138 VGND VGND VPWR VPWR sky130_fd_sc_hd__fill_2
X_1143_ _0457_ _0452_ _0468_ _0456_ _0470_ VGND VGND VPWR VPWR _0472_ sky130_fd_sc_hd__o2111a_1
X_1074_ net146 _0403_ _0402_ VGND VGND VPWR VPWR _0404_ sky130_fd_sc_hd__o21ai_1
XFILLER_25_308 VGND VGND VPWR VPWR sky130_fd_sc_hd__decap_3
X_0927_ net392 net82 _0085_ _0260_ VGND VGND VPWR VPWR _0046_ sky130_fd_sc_hd__a31o_1
X_0858_ _0212_ _0211_ net84 VGND VGND VPWR VPWR _0024_ sky130_fd_sc_hd__and3_1
X_0789_ net77 net38 net84 _0156_ VGND VGND VPWR VPWR _0011_ sky130_fd_sc_hd__o211a_1
XFILLER_51_193 VGND VGND VPWR VPWR sky130_fd_sc_hd__decap_8
XTAP_TAPCELL_ROW_41_339 VGND VPWR sky130_fd_sc_hd__tapvpwrvgnd_1
XFILLER_3_223 VGND VGND VPWR VPWR sky130_fd_sc_hd__fill_1
XFILLER_19_113 VPWR VGND VPWR VGND sky130_ef_sc_hd__decap_12
XFILLER_34_127 VPWR VGND VPWR VGND sky130_ef_sc_hd__decap_12
XFILLER_19_179 VPWR VGND VPWR VGND sky130_ef_sc_hd__decap_12
X_0712_ product_reg\[1\] net48 VGND VGND VPWR VPWR _0089_ sky130_fd_sc_hd__nor2_2
X_1126_ net104 net117 _0453_ _0454_ VGND VGND VPWR VPWR _0455_ sky130_fd_sc_hd__a22oi_4
X_1057_ _0386_ VGND VGND VPWR VPWR _0387_ sky130_fd_sc_hd__inv_2
XFILLER_31_49 VGND VGND VPWR VPWR sky130_fd_sc_hd__decap_6
Xoutput38 net38 VGND VGND VPWR VPWR psum[10] sky130_fd_sc_hd__buf_2
Xoutput27 net27 VGND VGND VPWR VPWR a_out[6] sky130_fd_sc_hd__buf_2
Xoutput49 net49 VGND VGND VPWR VPWR psum[20] sky130_fd_sc_hd__buf_2
XFILLER_21_93 VPWR VGND VPWR VGND sky130_ef_sc_hd__decap_12
Xclkbuf_0_clk clk VGND VGND VPWR VPWR clknet_0_clk sky130_fd_sc_hd__clkbuf_16
XPHY_EDGE_ROW_15_Left_68 VGND VGND VPWR VPWR sky130_fd_sc_hd__decap_3
XPHY_EDGE_ROW_15_Right_15 VGND VGND VPWR VPWR sky130_fd_sc_hd__decap_3
X_1109_ _0438_ VGND VGND VPWR VPWR _0439_ sky130_fd_sc_hd__inv_2
XPHY_EDGE_ROW_24_Right_24 VGND VGND VPWR VPWR sky130_fd_sc_hd__decap_3
XPHY_EDGE_ROW_33_Right_33 VGND VGND VPWR VPWR sky130_fd_sc_hd__decap_3
XTAP_TAPCELL_ROW_8_156 VGND VPWR sky130_fd_sc_hd__tapvpwrvgnd_1
XFILLER_44_299 VGND VGND VPWR VPWR sky130_fd_sc_hd__fill_1
XPHY_EDGE_ROW_42_Right_42 VGND VGND VPWR VPWR sky130_fd_sc_hd__decap_3
XPHY_EDGE_ROW_51_Right_51 VGND VGND VPWR VPWR sky130_fd_sc_hd__decap_3
X_1391_ clknet_3_2__leaf_clk _0017_ VGND VGND VPWR VPWR net44 sky130_fd_sc_hd__dfxtp_2
XFILLER_35_233 VGND VGND VPWR VPWR sky130_fd_sc_hd__decap_3
XFILLER_35_277 VGND VGND VPWR VPWR sky130_fd_sc_hd__decap_3
XFILLER_12_29 VGND VGND VPWR VPWR sky130_fd_sc_hd__fill_2
Xhold189 net19 VGND VGND VPWR VPWR net321 sky130_fd_sc_hd__dlygate4sd3_1
XFILLER_41_225 VPWR VGND VPWR VGND sky130_ef_sc_hd__decap_12
XFILLER_17_200 VGND VGND VPWR VPWR sky130_fd_sc_hd__decap_8
XTAP_TAPCELL_ROW_19_217 VGND VPWR sky130_fd_sc_hd__tapvpwrvgnd_1
X_0960_ net108 net123 net119 net110 VGND VGND VPWR VPWR _0292_ sky130_fd_sc_hd__a22o_1
XTAP_TAPCELL_ROW_27_261 VGND VPWR sky130_fd_sc_hd__tapvpwrvgnd_1
X_0891_ net353 net79 VGND VGND VPWR VPWR _0039_ sky130_fd_sc_hd__nor2_1
XFILLER_4_41 VGND VGND VPWR VPWR sky130_fd_sc_hd__decap_8
X_1374_ clknet_3_2__leaf_clk _0000_ VGND VGND VPWR VPWR v_pipe sky130_fd_sc_hd__dfxtp_1
XFILLER_23_203 VGND VGND VPWR VPWR sky130_fd_sc_hd__fill_1
XFILLER_23_225 VPWR VGND VPWR VGND sky130_ef_sc_hd__decap_12
XTAP_TAPCELL_ROW_33_297 VGND VPWR sky130_fd_sc_hd__tapvpwrvgnd_1
XFILLER_23_28 VPWR VGND VPWR VGND sky130_ef_sc_hd__decap_12
XPHY_EDGE_ROW_18_Left_71 VGND VGND VPWR VPWR sky130_fd_sc_hd__decap_3
Xfanout95 net96 VGND VGND VPWR VPWR net95 sky130_fd_sc_hd__buf_12
Xfanout84 net86 VGND VGND VPWR VPWR net84 sky130_fd_sc_hd__buf_2
XFILLER_1_173 VGND VGND VPWR VPWR sky130_fd_sc_hd__fill_1
XFILLER_52_309 VGND VGND VPWR VPWR sky130_fd_sc_hd__fill_2
X_1090_ _0406_ _0407_ _0413_ _0415_ VGND VGND VPWR VPWR _0420_ sky130_fd_sc_hd__o2bb2ai_4
X_0874_ _0195_ net150 _0193_ _0223_ VGND VGND VPWR VPWR _0224_ sky130_fd_sc_hd__o211a_1
XTAP_TAPCELL_ROW_30_278 VGND VPWR sky130_fd_sc_hd__tapvpwrvgnd_1
X_0943_ net110 net123 net119 net131 VGND VGND VPWR VPWR _0276_ sky130_fd_sc_hd__a22oi_1
X_1357_ net167 net387 net356 net386 _0677_ VGND VGND VPWR VPWR _0680_ sky130_fd_sc_hd__a2111oi_1
X_1288_ _0078_ _0080_ _0527_ _0608_ _0612_ VGND VGND VPWR VPWR _0614_ sky130_fd_sc_hd__o311a_4
XTAP_TAPCELL_ROW_38_323 VGND VPWR sky130_fd_sc_hd__tapvpwrvgnd_1
X_1426_ clknet_3_3__leaf_clk _0052_ VGND VGND VPWR VPWR product_reg\[9\] sky130_fd_sc_hd__dfxtp_2
XFILLER_50_15 VPWR VGND VPWR VGND sky130_ef_sc_hd__decap_12
Xclkload4 clknet_3_6__leaf_clk VGND VGND VPWR VPWR clkload4/Y sky130_fd_sc_hd__clkinv_2
XPHY_EDGE_ROW_3_Left_56 VGND VGND VPWR VPWR sky130_fd_sc_hd__decap_3
XFILLER_34_309 VGND VGND VPWR VPWR sky130_fd_sc_hd__fill_2
XFILLER_10_250 VGND VGND VPWR VPWR sky130_fd_sc_hd__fill_2
XFILLER_40_70 VGND VGND VPWR VPWR sky130_fd_sc_hd__decap_4
XFILLER_6_265 VGND VGND VPWR VPWR sky130_fd_sc_hd__fill_2
XFILLER_49_90 VGND VGND VPWR VPWR sky130_fd_sc_hd__decap_3
X_1211_ _0464_ _0466_ _0534_ _0535_ net145 VGND VGND VPWR VPWR _0539_ sky130_fd_sc_hd__o2111ai_4
XFILLER_37_136 VGND VGND VPWR VPWR sky130_fd_sc_hd__fill_1
X_1142_ _0457_ _0452_ _0456_ _0470_ VGND VGND VPWR VPWR _0471_ sky130_fd_sc_hd__o211ai_4
XFILLER_37_169 VPWR VGND VPWR VGND sky130_ef_sc_hd__decap_12
X_1073_ net90 net130 net94 net91 _0395_ VGND VGND VPWR VPWR _0403_ sky130_fd_sc_hd__a41o_1
XTAP_TAPCELL_ROW_35_304 VGND VPWR sky130_fd_sc_hd__tapvpwrvgnd_1
X_0857_ _0196_ net52 net77 net74 VGND VGND VPWR VPWR _0212_ sky130_fd_sc_hd__nand4_4
X_0926_ _0259_ net78 net81 net329 VGND VGND VPWR VPWR _0260_ sky130_fd_sc_hd__and4b_1
XPHY_EDGE_ROW_45_Left_98 VGND VGND VPWR VPWR sky130_fd_sc_hd__decap_3
X_1409_ clknet_3_0__leaf_clk _0035_ VGND VGND VPWR VPWR net21 sky130_fd_sc_hd__dfxtp_1
X_0788_ _0155_ _0154_ _0070_ VGND VGND VPWR VPWR _0156_ sky130_fd_sc_hd__a21o_1
XFILLER_45_26 VGND VGND VPWR VPWR sky130_fd_sc_hd__decap_3
XFILLER_43_106 VGND VGND VPWR VPWR sky130_fd_sc_hd__decap_6
XFILLER_16_309 VGND VGND VPWR VPWR sky130_fd_sc_hd__fill_2
XFILLER_28_125 VGND VGND VPWR VPWR sky130_fd_sc_hd__fill_1
XFILLER_10_73 VGND VGND VPWR VPWR sky130_fd_sc_hd__decap_3
XFILLER_19_125 VGND VGND VPWR VPWR sky130_fd_sc_hd__decap_4
XFILLER_35_70 VGND VGND VPWR VPWR sky130_fd_sc_hd__fill_1
XFILLER_34_139 VGND VGND VPWR VPWR sky130_fd_sc_hd__fill_1
XFILLER_34_106 VPWR VGND VPWR VGND sky130_ef_sc_hd__decap_12
XFILLER_19_93 VGND VGND VPWR VPWR sky130_fd_sc_hd__decap_8
X_0711_ _0087_ _0088_ VGND VGND VPWR VPWR _0001_ sky130_fd_sc_hd__nor2_1
XFILLER_32_3 VPWR VGND VPWR VGND sky130_ef_sc_hd__decap_12
X_1125_ net125 net101 net120 net98 VGND VGND VPWR VPWR _0454_ sky130_fd_sc_hd__nand4_4
XFILLER_40_109 VPWR VGND VPWR VGND sky130_ef_sc_hd__decap_12
XFILLER_33_183 VPWR VGND VPWR VGND sky130_ef_sc_hd__decap_12
XFILLER_33_150 VGND VGND VPWR VPWR sky130_fd_sc_hd__decap_8
XFILLER_31_17 VGND VGND VPWR VPWR sky130_fd_sc_hd__decap_6
X_1056_ _0340_ _0341_ _0343_ _0382_ VGND VGND VPWR VPWR _0386_ sky130_fd_sc_hd__o211ai_4
Xoutput28 net28 VGND VGND VPWR VPWR a_out[7] sky130_fd_sc_hd__buf_2
Xoutput39 net39 VGND VGND VPWR VPWR psum[11] sky130_fd_sc_hd__buf_2
X_0909_ _0242_ _0243_ net81 net78 VGND VGND VPWR VPWR _0244_ sky130_fd_sc_hd__and4b_1
XFILLER_0_238 VGND VGND VPWR VPWR sky130_fd_sc_hd__decap_3
XFILLER_7_74 VGND VGND VPWR VPWR sky130_fd_sc_hd__decap_3
X_1039_ _0359_ _0361_ _0369_ VGND VGND VPWR VPWR _0370_ sky130_fd_sc_hd__a21o_1
X_1108_ _0358_ _0380_ _0431_ _0432_ VGND VGND VPWR VPWR _0438_ sky130_fd_sc_hd__o211ai_4
XFILLER_26_17 VGND VGND VPWR VPWR sky130_fd_sc_hd__decap_8
XFILLER_21_131 VGND VGND VPWR VPWR sky130_fd_sc_hd__decap_4
XFILLER_21_164 VGND VGND VPWR VPWR sky130_fd_sc_hd__decap_4
XTAP_TAPCELL_ROW_8_157 VGND VPWR sky130_fd_sc_hd__tapvpwrvgnd_1
XPHY_EDGE_ROW_32_Left_85 VGND VGND VPWR VPWR sky130_fd_sc_hd__decap_3
XFILLER_16_83 VGND VGND VPWR VPWR sky130_fd_sc_hd__fill_1
XFILLER_8_157 VGND VGND VPWR VPWR sky130_fd_sc_hd__fill_2
X_1390_ clknet_3_7__leaf_clk _0016_ VGND VGND VPWR VPWR net43 sky130_fd_sc_hd__dfxtp_1
XFILLER_35_223 VGND VGND VPWR VPWR sky130_fd_sc_hd__fill_1
XFILLER_41_237 VPWR VGND VPWR VGND sky130_ef_sc_hd__decap_12
XTAP_TAPCELL_ROW_19_218 VGND VPWR sky130_fd_sc_hd__tapvpwrvgnd_1
X_0890_ net348 net80 VGND VGND VPWR VPWR _0038_ sky130_fd_sc_hd__nor2_1
XTAP_TAPCELL_ROW_27_262 VGND VPWR sky130_fd_sc_hd__tapvpwrvgnd_1
XFILLER_4_182 VPWR VGND VPWR VGND sky130_ef_sc_hd__decap_12
X_1373_ net366 net79 VGND VGND VPWR VPWR _0066_ sky130_fd_sc_hd__nor2_1
XFILLER_4_75 VGND VGND VPWR VPWR sky130_fd_sc_hd__fill_1
XFILLER_31_281 VGND VGND VPWR VPWR sky130_fd_sc_hd__decap_6
XFILLER_48_15 VPWR VGND VPWR VGND sky130_ef_sc_hd__decap_12
Xfanout96 net97 VGND VGND VPWR VPWR net96 sky130_fd_sc_hd__buf_8
Xfanout85 net86 VGND VGND VPWR VPWR net85 sky130_fd_sc_hd__buf_2
XFILLER_14_226 VPWR VGND VPWR VGND sky130_ef_sc_hd__decap_12
XTAP_TAPCELL_ROW_24_243 VGND VPWR sky130_fd_sc_hd__tapvpwrvgnd_1
Xfanout74 _0210_ VGND VGND VPWR VPWR net74 sky130_fd_sc_hd__buf_2
X_0873_ _0210_ _0216_ _0221_ VGND VGND VPWR VPWR _0223_ sky130_fd_sc_hd__and3_1
XTAP_TAPCELL_ROW_30_279 VGND VPWR sky130_fd_sc_hd__tapvpwrvgnd_1
X_0942_ net110 net131 net123 net119 VGND VGND VPWR VPWR _0275_ sky130_fd_sc_hd__and4_1
XFILLER_13_270 VGND VGND VPWR VPWR sky130_fd_sc_hd__decap_8
XFILLER_13_281 VPWR VGND VPWR VGND sky130_ef_sc_hd__decap_12
X_1425_ clknet_3_3__leaf_clk _0051_ VGND VGND VPWR VPWR product_reg\[8\] sky130_fd_sc_hd__dfxtp_1
X_1356_ net356 net87 _0632_ _0677_ VGND VGND VPWR VPWR _0679_ sky130_fd_sc_hd__o31a_1
X_1287_ _0608_ _0609_ _0611_ _0612_ VGND VGND VPWR VPWR _0613_ sky130_fd_sc_hd__a22oi_4
XTAP_TAPCELL_ROW_38_324 VGND VPWR sky130_fd_sc_hd__tapvpwrvgnd_1
Xclkload5 clknet_3_7__leaf_clk VGND VGND VPWR VPWR clkload5/X sky130_fd_sc_hd__clkbuf_4
XFILLER_50_27 VGND VGND VPWR VPWR sky130_fd_sc_hd__fill_1
XFILLER_6_244 VGND VGND VPWR VPWR sky130_fd_sc_hd__decap_8
XFILLER_10_262 VGND VGND VPWR VPWR sky130_fd_sc_hd__fill_2
XFILLER_24_83 VGND VGND VPWR VPWR sky130_fd_sc_hd__fill_1
X_1210_ _0464_ _0466_ _0536_ _0535_ _0534_ VGND VGND VPWR VPWR _0538_ sky130_fd_sc_hd__o2111a_1
X_1141_ _0329_ _0461_ _0460_ _0397_ _0465_ VGND VGND VPWR VPWR _0470_ sky130_fd_sc_hd__o2111ai_4
X_1072_ _0074_ _0077_ _0396_ _0398_ VGND VGND VPWR VPWR _0402_ sky130_fd_sc_hd__o22ai_4
XFILLER_45_181 VGND VGND VPWR VPWR sky130_fd_sc_hd__decap_4
XTAP_TAPCELL_ROW_35_305 VGND VPWR sky130_fd_sc_hd__tapvpwrvgnd_1
X_0856_ _0196_ net77 net74 net52 VGND VGND VPWR VPWR _0211_ sky130_fd_sc_hd__a31o_1
X_0925_ _0256_ _0257_ _0242_ VGND VGND VPWR VPWR _0259_ sky130_fd_sc_hd__a21oi_1
X_0787_ product_reg\[9\] net68 _0151_ _0152_ net173 VGND VGND VPWR VPWR _0155_ sky130_fd_sc_hd__o2111ai_4
X_1408_ clknet_3_7__leaf_clk _0034_ VGND VGND VPWR VPWR net70 sky130_fd_sc_hd__dfxtp_1
X_1339_ _0610_ _0661_ _0662_ VGND VGND VPWR VPWR _0663_ sky130_fd_sc_hd__o21ai_1
XFILLER_51_151 VGND VGND VPWR VPWR sky130_fd_sc_hd__decap_4
XFILLER_3_214 VGND VGND VPWR VPWR sky130_fd_sc_hd__fill_1
XFILLER_10_41 VGND VGND VPWR VPWR sky130_fd_sc_hd__decap_8
XFILLER_10_85 VPWR VGND VPWR VGND sky130_ef_sc_hd__decap_12
XFILLER_42_162 VPWR VGND VPWR VGND sky130_ef_sc_hd__decap_12
XFILLER_34_118 VGND VGND VPWR VPWR sky130_fd_sc_hd__decap_6
X_0710_ product_reg\[0\] net75 net37 net80 VGND VGND VPWR VPWR _0088_ sky130_fd_sc_hd__a31o_1
XFILLER_25_3 VPWR VGND VPWR VGND sky130_ef_sc_hd__decap_12
X_1124_ net101 net120 net98 net124 VGND VGND VPWR VPWR _0453_ sky130_fd_sc_hd__a22o_2
XFILLER_15_19 VGND VGND VPWR VPWR sky130_fd_sc_hd__fill_1
X_1055_ _0383_ net114 net111 _0342_ VGND VGND VPWR VPWR _0385_ sky130_fd_sc_hd__nand4_2
XFILLER_33_195 VPWR VGND VPWR VGND sky130_ef_sc_hd__decap_12
X_0908_ _0240_ _0241_ net331 VGND VGND VPWR VPWR _0243_ sky130_fd_sc_hd__o21ai_1
Xoutput29 net29 VGND VGND VPWR VPWR b_out[0] sky130_fd_sc_hd__buf_2
X_0839_ net76 net45 net44 net287 VGND VGND VPWR VPWR _0200_ sky130_fd_sc_hd__nand4_1
XFILLER_21_51 VGND VGND VPWR VPWR sky130_fd_sc_hd__decap_4
XPHY_EDGE_ROW_5_Right_5 VGND VGND VPWR VPWR sky130_fd_sc_hd__decap_3
X_1038_ _0366_ _0367_ VGND VGND VPWR VPWR _0369_ sky130_fd_sc_hd__nand2_2
X_1107_ _0433_ _0381_ _0434_ VGND VGND VPWR VPWR _0437_ sky130_fd_sc_hd__nand3_4
XFILLER_21_198 VGND VGND VPWR VPWR sky130_fd_sc_hd__fill_2
XTAP_TAPCELL_ROW_8_158 VGND VPWR sky130_fd_sc_hd__tapvpwrvgnd_1
XFILLER_35_257 VPWR VGND VPWR VGND sky130_ef_sc_hd__decap_12
XTAP_TAPCELL_ROW_5_139 VGND VPWR sky130_fd_sc_hd__tapvpwrvgnd_1
XFILLER_41_249 VGND VGND VPWR VPWR sky130_fd_sc_hd__decap_4
XFILLER_41_205 VGND VGND VPWR VPWR sky130_fd_sc_hd__decap_3
XFILLER_34_290 VGND VGND VPWR VPWR sky130_fd_sc_hd__fill_2
XTAP_TAPCELL_ROW_19_219 VGND VPWR sky130_fd_sc_hd__tapvpwrvgnd_1
XFILLER_27_61 VGND VGND VPWR VPWR sky130_fd_sc_hd__decap_3
XTAP_TAPCELL_ROW_27_263 VGND VPWR sky130_fd_sc_hd__tapvpwrvgnd_1
XFILLER_4_194 VGND VGND VPWR VPWR sky130_fd_sc_hd__fill_2
X_1372_ net354 net79 VGND VGND VPWR VPWR _0065_ sky130_fd_sc_hd__nor2_1
XFILLER_48_27 VGND VGND VPWR VPWR sky130_fd_sc_hd__fill_1
XTAP_TAPCELL_ROW_1_120 VGND VPWR sky130_fd_sc_hd__tapvpwrvgnd_1
XFILLER_14_238 VGND VGND VPWR VPWR sky130_fd_sc_hd__fill_2
Xfanout97 net7 VGND VGND VPWR VPWR net97 sky130_fd_sc_hd__buf_6
Xfanout75 net76 VGND VGND VPWR VPWR net75 sky130_fd_sc_hd__buf_2
Xfanout86 _0082_ VGND VGND VPWR VPWR net86 sky130_fd_sc_hd__clkbuf_2
XTAP_TAPCELL_ROW_24_244 VGND VPWR sky130_fd_sc_hd__tapvpwrvgnd_1
XFILLER_49_113 VGND VGND VPWR VPWR sky130_fd_sc_hd__fill_2
X_0941_ net110 net119 VGND VGND VPWR VPWR _0274_ sky130_fd_sc_hd__nand2_1
X_0872_ net74 _0216_ _0221_ VGND VGND VPWR VPWR _0222_ sky130_fd_sc_hd__and3_1
XFILLER_13_293 VGND VGND VPWR VPWR sky130_fd_sc_hd__fill_2
X_1355_ net356 net366 net397 _0677_ VGND VGND VPWR VPWR _0678_ sky130_fd_sc_hd__or4b_1
X_1424_ clknet_3_3__leaf_clk _0050_ VGND VGND VPWR VPWR product_reg\[7\] sky130_fd_sc_hd__dfxtp_1
X_1286_ net169 net118 net93 net121 VGND VGND VPWR VPWR _0612_ sky130_fd_sc_hd__a22o_1
XTAP_TAPCELL_ROW_38_325 VGND VPWR sky130_fd_sc_hd__tapvpwrvgnd_1
XFILLER_34_29 VPWR VGND VPWR VGND sky130_ef_sc_hd__decap_12
XFILLER_10_230 VPWR VGND VPWR VGND sky130_ef_sc_hd__decap_12
XFILLER_24_62 VGND VGND VPWR VPWR sky130_fd_sc_hd__decap_3
XFILLER_52_119 VGND VGND VPWR VPWR sky130_fd_sc_hd__decap_3
X_1140_ _0329_ _0461_ _0465_ _0397_ _0460_ VGND VGND VPWR VPWR _0469_ sky130_fd_sc_hd__o2111a_1
XTAP_TAPCELL_ROW_35_306 VGND VPWR sky130_fd_sc_hd__tapvpwrvgnd_1
X_1071_ _0396_ _0398_ _0395_ VGND VGND VPWR VPWR _0401_ sky130_fd_sc_hd__o21bai_2
XFILLER_1_55 VGND VGND VPWR VPWR sky130_fd_sc_hd__fill_1
XTAP_TAPCELL_ROW_43_350 VGND VPWR sky130_fd_sc_hd__tapvpwrvgnd_1
X_0924_ _0256_ _0257_ _0242_ VGND VGND VPWR VPWR _0258_ sky130_fd_sc_hd__nand3_1
X_0855_ net279 net74 _0209_ net79 VGND VGND VPWR VPWR _0023_ sky130_fd_sc_hd__a211oi_2
X_0786_ _0151_ _0152_ _0153_ _0146_ VGND VGND VPWR VPWR _0154_ sky130_fd_sc_hd__a22o_1
X_1407_ clknet_3_4__leaf_clk _0033_ VGND VGND VPWR VPWR net69 sky130_fd_sc_hd__dfxtp_1
X_1338_ _0639_ _0660_ VGND VGND VPWR VPWR _0662_ sky130_fd_sc_hd__nand2_1
XFILLER_36_182 VGND VGND VPWR VPWR sky130_fd_sc_hd__fill_1
X_1269_ _0595_ _0594_ _0592_ VGND VGND VPWR VPWR _0596_ sky130_fd_sc_hd__nand3b_1
XFILLER_10_97 VGND VGND VPWR VPWR sky130_fd_sc_hd__fill_2
XFILLER_42_174 VGND VGND VPWR VPWR sky130_fd_sc_hd__decap_8
XTAP_TAPCELL_ROW_40_331 VGND VPWR sky130_fd_sc_hd__tapvpwrvgnd_1
XFILLER_35_94 VGND VGND VPWR VPWR sky130_fd_sc_hd__fill_2
XFILLER_2_281 VGND VGND VPWR VPWR sky130_fd_sc_hd__decap_3
X_1123_ net101 net120 net98 net124 VGND VGND VPWR VPWR _0452_ sky130_fd_sc_hd__a22oi_4
X_1054_ _0383_ net111 _0342_ net114 VGND VGND VPWR VPWR _0384_ sky130_fd_sc_hd__and4_2
X_0907_ _0234_ _0240_ _0241_ VGND VGND VPWR VPWR _0242_ sky130_fd_sc_hd__nor3_2
X_0769_ product_reg\[8\] net67 VGND VGND VPWR VPWR _0139_ sky130_fd_sc_hd__or2_1
X_0838_ net76 net44 _0196_ net45 VGND VGND VPWR VPWR _0199_ sky130_fd_sc_hd__a31o_1
XFILLER_15_130 VGND VGND VPWR VPWR sky130_fd_sc_hd__decap_6
XFILLER_38_277 VGND VGND VPWR VPWR sky130_fd_sc_hd__decap_3
XFILLER_38_200 VPWR VGND VPWR VGND sky130_ef_sc_hd__decap_12
X_1106_ _0434_ net231 _0433_ VGND VGND VPWR VPWR _0436_ sky130_fd_sc_hd__and3_1
X_1037_ _0362_ _0365_ VGND VGND VPWR VPWR _0368_ sky130_fd_sc_hd__xor2_1
XTAP_TAPCELL_ROW_8_159 VGND VPWR sky130_fd_sc_hd__tapvpwrvgnd_1
XPHY_EDGE_ROW_11_Right_11 VGND VGND VPWR VPWR sky130_fd_sc_hd__decap_3
XFILLER_12_100 VGND VGND VPWR VPWR sky130_fd_sc_hd__fill_2
XFILLER_12_111 VPWR VGND VPWR VGND sky130_ef_sc_hd__decap_12
XFILLER_16_85 VGND VGND VPWR VPWR sky130_fd_sc_hd__decap_4
XPHY_EDGE_ROW_20_Right_20 VGND VGND VPWR VPWR sky130_fd_sc_hd__decap_3
XFILLER_35_269 VGND VGND VPWR VPWR sky130_fd_sc_hd__decap_8
XFILLER_35_225 VGND VGND VPWR VPWR sky130_fd_sc_hd__decap_8
XTAP_TAPCELL_ROW_13_183 VGND VPWR sky130_fd_sc_hd__tapvpwrvgnd_1
XFILLER_17_225 VGND VGND VPWR VPWR sky130_fd_sc_hd__decap_4
XFILLER_17_269 VGND VGND VPWR VPWR sky130_fd_sc_hd__decap_6
XTAP_TAPCELL_ROW_27_264 VGND VPWR sky130_fd_sc_hd__tapvpwrvgnd_1
X_1440_ clknet_3_5__leaf_clk _0066_ VGND VGND VPWR VPWR net36 sky130_fd_sc_hd__dfxtp_1
X_1371_ net361 net79 VGND VGND VPWR VPWR _0064_ sky130_fd_sc_hd__nor2_1
XFILLER_4_162 VPWR VGND VPWR VGND sky130_ef_sc_hd__decap_12
XFILLER_4_99 VPWR VGND VPWR VGND sky130_ef_sc_hd__decap_12
XFILLER_4_55 VPWR VGND VPWR VGND sky130_ef_sc_hd__decap_12
XFILLER_31_294 VGND VGND VPWR VPWR sky130_fd_sc_hd__decap_8
Xclkbuf_3_2__f_clk clknet_0_clk VGND VGND VPWR VPWR clknet_3_2__leaf_clk sky130_fd_sc_hd__clkbuf_16
XFILLER_16_280 VGND VGND VPWR VPWR sky130_fd_sc_hd__decap_6
XFILLER_46_309 VGND VGND VPWR VPWR sky130_fd_sc_hd__fill_2
XTAP_TAPCELL_ROW_1_121 VGND VPWR sky130_fd_sc_hd__tapvpwrvgnd_1
Xfanout87 _0081_ VGND VGND VPWR VPWR net87 sky130_fd_sc_hd__clkbuf_4
Xfanout98 net6 VGND VGND VPWR VPWR net98 sky130_fd_sc_hd__buf_4
Xfanout76 v_pipe VGND VGND VPWR VPWR net76 sky130_fd_sc_hd__buf_2
XTAP_TAPCELL_ROW_24_245 VGND VPWR sky130_fd_sc_hd__tapvpwrvgnd_1
XFILLER_1_132 VPWR VGND VPWR VGND sky130_ef_sc_hd__decap_12
XFILLER_37_309 VGND VGND VPWR VPWR sky130_fd_sc_hd__fill_2
X_0940_ _0265_ _0271_ _0262_ _0270_ VGND VGND VPWR VPWR _0273_ sky130_fd_sc_hd__o211ai_4
XFILLER_20_209 VPWR VGND VPWR VGND sky130_ef_sc_hd__decap_12
X_0871_ v_pipe net56 net55 VGND VGND VPWR VPWR _0221_ sky130_fd_sc_hd__and3_1
XPHY_EDGE_ROW_50_Left_103 VGND VGND VPWR VPWR sky130_fd_sc_hd__decap_3
X_1354_ _0610_ _0661_ _0662_ _0658_ VGND VGND VPWR VPWR _0677_ sky130_fd_sc_hd__a2bb2o_1
X_1285_ net121 net165 net118 net93 VGND VGND VPWR VPWR _0611_ sky130_fd_sc_hd__nand4_4
XFILLER_48_3 VPWR VGND VPWR VGND sky130_ef_sc_hd__decap_12
X_1423_ clknet_3_1__leaf_clk _0049_ VGND VGND VPWR VPWR product_reg\[6\] sky130_fd_sc_hd__dfxtp_1
XFILLER_28_309 VGND VGND VPWR VPWR sky130_fd_sc_hd__fill_2
XFILLER_50_29 VGND VGND VPWR VPWR sky130_fd_sc_hd__decap_8
XFILLER_46_139 VGND VGND VPWR VPWR sky130_fd_sc_hd__fill_1
XFILLER_10_242 VGND VGND VPWR VPWR sky130_fd_sc_hd__decap_8
XFILLER_10_253 VGND VGND VPWR VPWR sky130_fd_sc_hd__decap_4
XFILLER_34_9 VGND VGND VPWR VPWR sky130_fd_sc_hd__fill_1
XFILLER_52_109 VGND VGND VPWR VPWR sky130_fd_sc_hd__decap_3
X_1070_ _0074_ _0077_ _0397_ _0399_ VGND VGND VPWR VPWR _0400_ sky130_fd_sc_hd__o211ai_2
XFILLER_37_128 VGND VGND VPWR VPWR sky130_fd_sc_hd__decap_8
XTAP_TAPCELL_ROW_35_307 VGND VPWR sky130_fd_sc_hd__tapvpwrvgnd_1
XTAP_TAPCELL_ROW_43_351 VGND VPWR sky130_fd_sc_hd__tapvpwrvgnd_1
X_0923_ net388 net123 _0254_ _0255_ VGND VGND VPWR VPWR _0257_ sky130_fd_sc_hd__a22o_1
X_0854_ net51 net50 net49 _0204_ VGND VGND VPWR VPWR _0210_ sky130_fd_sc_hd__and4_1
XPHY_EDGE_ROW_49_Right_49 VGND VGND VPWR VPWR sky130_fd_sc_hd__decap_3
X_0785_ _0138_ _0145_ _0144_ VGND VGND VPWR VPWR _0153_ sky130_fd_sc_hd__nand3_4
X_1406_ clknet_3_7__leaf_clk _0032_ VGND VGND VPWR VPWR net61 sky130_fd_sc_hd__dfxtp_1
X_1337_ _0636_ _0637_ _0660_ VGND VGND VPWR VPWR _0661_ sky130_fd_sc_hd__a21o_1
XFILLER_45_18 VGND VGND VPWR VPWR sky130_fd_sc_hd__decap_8
X_1268_ net108 net112 _0543_ _0541_ VGND VGND VPWR VPWR _0595_ sky130_fd_sc_hd__a31oi_2
XFILLER_28_139 VGND VGND VPWR VPWR sky130_fd_sc_hd__fill_1
X_1199_ net120 net169 VGND VGND VPWR VPWR _0527_ sky130_fd_sc_hd__nand2_1
XFILLER_36_161 VGND VGND VPWR VPWR sky130_fd_sc_hd__decap_4
XFILLER_3_249 VGND VGND VPWR VPWR sky130_fd_sc_hd__decap_3
XFILLER_10_65 VGND VGND VPWR VPWR sky130_fd_sc_hd__decap_8
XFILLER_19_30 VGND VGND VPWR VPWR sky130_fd_sc_hd__fill_1
XFILLER_42_197 VPWR VGND VPWR VGND sky130_ef_sc_hd__decap_12
XTAP_TAPCELL_ROW_40_332 VGND VPWR sky130_fd_sc_hd__tapvpwrvgnd_1
X_1122_ net104 net117 VGND VGND VPWR VPWR _0451_ sky130_fd_sc_hd__nand2_1
XFILLER_18_194 VGND VGND VPWR VPWR sky130_fd_sc_hd__fill_2
X_1053_ _0340_ _0343_ VGND VGND VPWR VPWR _0383_ sky130_fd_sc_hd__nand2_1
X_0906_ _0237_ _0239_ net126 net131 VGND VGND VPWR VPWR _0241_ sky130_fd_sc_hd__and4b_1
X_0837_ net368 net279 _0198_ VGND VGND VPWR VPWR _0017_ sky130_fd_sc_hd__a21oi_1
X_0699_ net114 VGND VGND VPWR VPWR _0079_ sky130_fd_sc_hd__inv_4
X_0768_ product_reg\[8\] net67 VGND VGND VPWR VPWR _0138_ sky130_fd_sc_hd__nand2_1
XFILLER_24_120 VGND VGND VPWR VPWR sky130_fd_sc_hd__decap_4
XFILLER_47_223 VGND VGND VPWR VPWR sky130_fd_sc_hd__fill_1
XFILLER_47_267 VGND VGND VPWR VPWR sky130_fd_sc_hd__fill_1
Xmax_cap73 _0680_ VGND VGND VPWR VPWR net73 sky130_fd_sc_hd__clkbuf_1
XFILLER_15_153 VPWR VGND VPWR VGND sky130_ef_sc_hd__decap_12
XFILLER_7_99 VGND VGND VPWR VPWR sky130_fd_sc_hd__fill_1
XFILLER_30_3 VGND VGND VPWR VPWR sky130_fd_sc_hd__decap_4
XFILLER_38_212 VPWR VGND VPWR VGND sky130_ef_sc_hd__decap_12
X_1105_ _0431_ _0432_ VGND VGND VPWR VPWR _0435_ sky130_fd_sc_hd__nand2_1
X_1036_ _0291_ _0363_ net132 net114 VGND VGND VPWR VPWR _0367_ sky130_fd_sc_hd__a2bb2o_1
XFILLER_52_281 VPWR VGND VPWR VGND sky130_ef_sc_hd__decap_12
XFILLER_32_85 VPWR VGND VPWR VGND sky130_ef_sc_hd__decap_12
XFILLER_8_149 VGND VGND VPWR VPWR sky130_fd_sc_hd__decap_8
XFILLER_12_123 VGND VGND VPWR VPWR sky130_fd_sc_hd__decap_6
XFILLER_43_281 VGND VGND VPWR VPWR sky130_fd_sc_hd__decap_8
XTAP_TAPCELL_ROW_13_184 VGND VPWR sky130_fd_sc_hd__tapvpwrvgnd_1
X_1019_ _0346_ _0342_ _0344_ VGND VGND VPWR VPWR _0350_ sky130_fd_sc_hd__a21oi_2
XPHY_EDGE_ROW_36_Left_89 VGND VGND VPWR VPWR sky130_fd_sc_hd__decap_3
XFILLER_25_281 VGND VGND VPWR VPWR sky130_fd_sc_hd__decap_8
XFILLER_4_130 VGND VGND VPWR VPWR sky130_fd_sc_hd__decap_6
XFILLER_4_174 VGND VGND VPWR VPWR sky130_fd_sc_hd__decap_3
XFILLER_4_67 VGND VGND VPWR VPWR sky130_fd_sc_hd__decap_8
X_1370_ net357 net81 VGND VGND VPWR VPWR _0063_ sky130_fd_sc_hd__and2_1
XTAP_TAPCELL_ROW_18_210 VGND VPWR sky130_fd_sc_hd__tapvpwrvgnd_1
XTAP_TAPCELL_ROW_24_246 VGND VPWR sky130_fd_sc_hd__tapvpwrvgnd_1
Xfanout99 net100 VGND VGND VPWR VPWR net99 sky130_fd_sc_hd__buf_2
XTAP_TAPCELL_ROW_32_290 VGND VPWR sky130_fd_sc_hd__tapvpwrvgnd_1
XFILLER_13_54 VGND VGND VPWR VPWR sky130_fd_sc_hd__fill_2
Xfanout88 net89 VGND VGND VPWR VPWR net88 sky130_fd_sc_hd__buf_8
Xfanout77 v_pipe VGND VGND VPWR VPWR net77 sky130_fd_sc_hd__buf_2
XFILLER_1_111 VGND VGND VPWR VPWR sky130_fd_sc_hd__fill_1
XFILLER_1_144 VGND VGND VPWR VPWR sky130_fd_sc_hd__decap_6
XFILLER_1_166 VGND VGND VPWR VPWR sky130_fd_sc_hd__fill_2
XFILLER_8_3 VPWR VGND VPWR VGND sky130_ef_sc_hd__decap_12
XFILLER_38_62 VGND VGND VPWR VPWR sky130_fd_sc_hd__decap_4
X_0870_ net384 net367 _0218_ net79 _0220_ VGND VGND VPWR VPWR _0028_ sky130_fd_sc_hd__a311oi_1
X_1422_ clknet_3_1__leaf_clk _0048_ VGND VGND VPWR VPWR product_reg\[5\] sky130_fd_sc_hd__dfxtp_1
X_1284_ net117 net395 VGND VGND VPWR VPWR _0610_ sky130_fd_sc_hd__nand2_1
X_1353_ _0653_ _0654_ _0672_ _0675_ VGND VGND VPWR VPWR _0676_ sky130_fd_sc_hd__a31oi_1
X_0999_ net89 net129 net223 net100 VGND VGND VPWR VPWR _0330_ sky130_fd_sc_hd__and4_1
XTAP_TAPCELL_ROW_21_227 VGND VPWR sky130_fd_sc_hd__tapvpwrvgnd_1
XFILLER_39_181 VGND VGND VPWR VPWR sky130_fd_sc_hd__decap_8
XFILLER_40_85 VPWR VGND VPWR VGND sky130_ef_sc_hd__decap_12
XFILLER_6_236 VGND VGND VPWR VPWR sky130_fd_sc_hd__fill_1
XFILLER_49_72 VGND VGND VPWR VPWR sky130_fd_sc_hd__decap_4
XPHY_EDGE_ROW_39_Left_92 VGND VGND VPWR VPWR sky130_fd_sc_hd__decap_3
XFILLER_27_9 VGND VGND VPWR VPWR sky130_fd_sc_hd__fill_1
XFILLER_45_140 VPWR VGND VPWR VGND sky130_ef_sc_hd__decap_12
XTAP_TAPCELL_ROW_43_352 VGND VPWR sky130_fd_sc_hd__tapvpwrvgnd_1
XTAP_TAPCELL_ROW_35_308 VGND VPWR sky130_fd_sc_hd__tapvpwrvgnd_1
XFILLER_1_57 VPWR VGND VPWR VGND sky130_ef_sc_hd__decap_12
XPHY_EDGE_ROW_23_Left_76 VGND VGND VPWR VPWR sky130_fd_sc_hd__decap_3
X_0922_ _0250_ _0251_ _0252_ _0245_ _0253_ VGND VGND VPWR VPWR _0256_ sky130_fd_sc_hd__a311o_1
X_0853_ net71 net49 net50 _0204_ net382 VGND VGND VPWR VPWR _0209_ sky130_fd_sc_hd__a41oi_2
X_1405_ clknet_3_7__leaf_clk _0031_ VGND VGND VPWR VPWR net60 sky130_fd_sc_hd__dfxtp_1
X_0784_ product_reg\[10\] net38 VGND VGND VPWR VPWR _0152_ sky130_fd_sc_hd__or2_1
X_1336_ net93 net113 _0632_ _0659_ VGND VGND VPWR VPWR _0660_ sky130_fd_sc_hd__a31o_1
X_1198_ net125 net217 net99 net120 VGND VGND VPWR VPWR _0526_ sky130_fd_sc_hd__a22o_1
X_1267_ _0590_ _0589_ _0588_ VGND VGND VPWR VPWR _0594_ sky130_fd_sc_hd__nand3_1
Xinput1 a_in[0] VGND VGND VPWR VPWR net1 sky130_fd_sc_hd__clkbuf_1
XFILLER_51_165 VGND VGND VPWR VPWR sky130_fd_sc_hd__decap_3
XFILLER_51_110 VGND VGND VPWR VPWR sky130_fd_sc_hd__fill_2
XFILLER_27_151 VGND VGND VPWR VPWR sky130_fd_sc_hd__decap_8
XFILLER_51_51 VGND VGND VPWR VPWR sky130_fd_sc_hd__decap_4
XTAP_TAPCELL_ROW_40_333 VGND VPWR sky130_fd_sc_hd__tapvpwrvgnd_1
X_1121_ product_reg\[7\] _0232_ _0450_ _0449_ VGND VGND VPWR VPWR _0050_ sky130_fd_sc_hd__a22o_1
X_1052_ net111 net114 VGND VGND VPWR VPWR _0382_ sky130_fd_sc_hd__nand2_1
X_0905_ _0074_ _0075_ _0237_ _0238_ VGND VGND VPWR VPWR _0240_ sky130_fd_sc_hd__o22a_1
X_0767_ _0135_ _0136_ net76 _0137_ VGND VGND VPWR VPWR _0008_ sky130_fd_sc_hd__a31oi_1
X_0836_ net44 net279 net83 VGND VGND VPWR VPWR _0198_ sky130_fd_sc_hd__o21ai_2
X_0698_ net117 VGND VGND VPWR VPWR _0078_ sky130_fd_sc_hd__clkinv_4
XFILLER_0_209 VPWR VGND VPWR VGND sky130_ef_sc_hd__decap_12
X_1319_ _0631_ _0641_ _0642_ VGND VGND VPWR VPWR _0644_ sky130_fd_sc_hd__and3_1
XFILLER_8_309 VGND VGND VPWR VPWR sky130_fd_sc_hd__fill_2
XFILLER_12_305 VGND VGND VPWR VPWR sky130_fd_sc_hd__decap_3
XFILLER_46_73 VGND VGND VPWR VPWR sky130_fd_sc_hd__fill_2
XFILLER_15_110 VGND VGND VPWR VPWR sky130_fd_sc_hd__fill_2
XFILLER_15_165 VGND VGND VPWR VPWR sky130_fd_sc_hd__decap_3
XFILLER_30_157 VPWR VGND VPWR VGND sky130_ef_sc_hd__decap_12
XFILLER_38_224 VGND VGND VPWR VPWR sky130_fd_sc_hd__decap_6
X_1035_ _0075_ _0079_ _0291_ _0363_ VGND VGND VPWR VPWR _0366_ sky130_fd_sc_hd__or4_4
X_1104_ _0388_ _0389_ _0427_ _0429_ VGND VGND VPWR VPWR _0434_ sky130_fd_sc_hd__o22ai_2
XFILLER_21_146 VGND VGND VPWR VPWR sky130_fd_sc_hd__fill_2
X_0819_ _0173_ net40 product_reg\[12\] _0174_ VGND VGND VPWR VPWR _0183_ sky130_fd_sc_hd__a31o_1
XPHY_EDGE_ROW_10_Left_63 VGND VGND VPWR VPWR sky130_fd_sc_hd__decap_3
XFILLER_29_268 VGND VGND VPWR VPWR sky130_fd_sc_hd__decap_8
XFILLER_52_293 VPWR VGND VPWR VGND sky130_ef_sc_hd__decap_12
XFILLER_32_97 VGND VGND VPWR VPWR sky130_fd_sc_hd__decap_8
XTAP_TAPCELL_ROW_7_150 VGND VPWR sky130_fd_sc_hd__tapvpwrvgnd_1
XFILLER_35_205 VPWR VGND VPWR VGND sky130_ef_sc_hd__decap_12
XFILLER_28_290 VGND VGND VPWR VPWR sky130_fd_sc_hd__fill_2
XPHY_EDGE_ROW_9_Right_9 VGND VGND VPWR VPWR sky130_fd_sc_hd__decap_3
XTAP_TAPCELL_ROW_13_185 VGND VPWR sky130_fd_sc_hd__tapvpwrvgnd_1
X_1018_ _0341_ _0347_ _0345_ VGND VGND VPWR VPWR _0349_ sky130_fd_sc_hd__o21ai_1
XFILLER_49_308 VGND VGND VPWR VPWR sky130_fd_sc_hd__decap_3
XFILLER_27_53 VGND VGND VPWR VPWR sky130_fd_sc_hd__decap_3
XFILLER_40_241 VGND VGND VPWR VPWR sky130_fd_sc_hd__decap_8
Xclone95 net95 VGND VGND VPWR VPWR net227 sky130_fd_sc_hd__clkbuf_2
XFILLER_4_153 VGND VGND VPWR VPWR sky130_fd_sc_hd__fill_1
XTAP_TAPCELL_ROW_10_166 VGND VPWR sky130_fd_sc_hd__tapvpwrvgnd_1
XFILLER_4_197 VPWR VGND VPWR VGND sky130_ef_sc_hd__decap_12
XTAP_TAPCELL_ROW_18_211 VGND VPWR sky130_fd_sc_hd__tapvpwrvgnd_1
Xfanout78 _0084_ VGND VGND VPWR VPWR net78 sky130_fd_sc_hd__buf_2
XFILLER_14_219 VGND VGND VPWR VPWR sky130_fd_sc_hd__fill_1
Xfanout89 net90 VGND VGND VPWR VPWR net89 sky130_fd_sc_hd__buf_6
XTAP_TAPCELL_ROW_24_247 VGND VPWR sky130_fd_sc_hd__tapvpwrvgnd_1
XTAP_TAPCELL_ROW_32_291 VGND VPWR sky130_fd_sc_hd__tapvpwrvgnd_1
XFILLER_38_85 VPWR VGND VPWR VGND sky130_ef_sc_hd__decap_12
XFILLER_9_223 VGND VGND VPWR VPWR sky130_fd_sc_hd__fill_1
XFILLER_9_278 VGND VGND VPWR VPWR sky130_fd_sc_hd__fill_2
X_1421_ clknet_3_1__leaf_clk _0047_ VGND VGND VPWR VPWR product_reg\[4\] sky130_fd_sc_hd__dfxtp_1
X_1283_ _0606_ _0607_ net362 net113 VGND VGND VPWR VPWR _0609_ sky130_fd_sc_hd__nand4_4
X_1352_ _0674_ VGND VGND VPWR VPWR _0675_ sky130_fd_sc_hd__inv_2
X_0998_ net209 net227 VGND VGND VPWR VPWR _0329_ sky130_fd_sc_hd__nand2_2
XTAP_TAPCELL_ROW_21_228 VGND VPWR sky130_fd_sc_hd__tapvpwrvgnd_1
XTAP_TAPCELL_ROW_52_397 VGND VPWR sky130_fd_sc_hd__tapvpwrvgnd_1
XFILLER_24_54 VGND VGND VPWR VPWR sky130_fd_sc_hd__decap_8
XFILLER_24_76 VGND VGND VPWR VPWR sky130_fd_sc_hd__fill_1
XFILLER_40_97 VPWR VGND VPWR VGND sky130_ef_sc_hd__decap_12
XFILLER_1_69 VPWR VGND VPWR VGND sky130_ef_sc_hd__decap_12
XFILLER_45_196 VGND VGND VPWR VPWR sky130_fd_sc_hd__fill_1
XFILLER_45_185 VGND VGND VPWR VPWR sky130_fd_sc_hd__fill_1
X_0921_ _0250_ _0251_ _0252_ VGND VGND VPWR VPWR _0255_ sky130_fd_sc_hd__nand3_1
X_0852_ _0208_ _0205_ net83 _0207_ VGND VGND VPWR VPWR _0022_ sky130_fd_sc_hd__o211a_1
X_0783_ product_reg\[10\] net38 VGND VGND VPWR VPWR _0151_ sky130_fd_sc_hd__nand2_2
X_1404_ clknet_3_7__leaf_clk _0030_ VGND VGND VPWR VPWR net58 sky130_fd_sc_hd__dfxtp_1
X_1335_ net115 net93 net113 net166 VGND VGND VPWR VPWR _0659_ sky130_fd_sc_hd__a22oi_1
X_1197_ net125 net217 net99 net120 VGND VGND VPWR VPWR _0525_ sky130_fd_sc_hd__a22oi_4
X_1266_ _0590_ _0589_ _0588_ VGND VGND VPWR VPWR _0593_ sky130_fd_sc_hd__and3_1
Xinput2 a_in[1] VGND VGND VPWR VPWR net2 sky130_fd_sc_hd__clkbuf_2
XFILLER_10_56 VGND VGND VPWR VPWR sky130_fd_sc_hd__decap_3
XPHY_EDGE_ROW_40_Left_93 VGND VGND VPWR VPWR sky130_fd_sc_hd__decap_3
XFILLER_19_108 VGND VGND VPWR VPWR sky130_fd_sc_hd__decap_4
XFILLER_35_42 VGND VGND VPWR VPWR sky130_fd_sc_hd__fill_2
XTAP_TAPCELL_ROW_40_334 VGND VPWR sky130_fd_sc_hd__tapvpwrvgnd_1
XFILLER_2_273 VGND VGND VPWR VPWR sky130_fd_sc_hd__decap_8
X_1051_ _0351_ _0352_ _0356_ _0369_ _0361_ VGND VGND VPWR VPWR _0381_ sky130_fd_sc_hd__a32oi_4
X_1120_ _0379_ _0448_ _0086_ VGND VGND VPWR VPWR _0450_ sky130_fd_sc_hd__a21oi_1
XFILLER_18_163 VGND VGND VPWR VPWR sky130_fd_sc_hd__decap_6
XFILLER_33_166 VGND VGND VPWR VPWR sky130_fd_sc_hd__fill_2
X_0904_ net89 net106 net109 net310 VGND VGND VPWR VPWR _0239_ sky130_fd_sc_hd__a22o_1
X_0697_ net98 VGND VGND VPWR VPWR _0077_ sky130_fd_sc_hd__clkinv_4
XPHY_EDGE_ROW_47_Left_100 VGND VGND VPWR VPWR sky130_fd_sc_hd__decap_3
X_0835_ _0182_ _0195_ net77 _0193_ VGND VGND VPWR VPWR _0197_ sky130_fd_sc_hd__o211a_1
X_0766_ _0070_ _0071_ net317 net315 VGND VGND VPWR VPWR _0137_ sky130_fd_sc_hd__a211o_1
X_1318_ _0641_ _0642_ _0631_ VGND VGND VPWR VPWR _0643_ sky130_fd_sc_hd__a21oi_1
X_1249_ net98 net117 VGND VGND VPWR VPWR _0576_ sky130_fd_sc_hd__nand2_2
XFILLER_24_133 VGND VGND VPWR VPWR sky130_fd_sc_hd__decap_6
XFILLER_21_55 VGND VGND VPWR VPWR sky130_fd_sc_hd__fill_1
XFILLER_47_225 VPWR VGND VPWR VGND sky130_ef_sc_hd__decap_12
XFILLER_30_169 VPWR VGND VPWR VGND sky130_ef_sc_hd__decap_12
XFILLER_15_177 VGND VGND VPWR VPWR sky130_fd_sc_hd__fill_1
XFILLER_7_35 VGND VGND VPWR VPWR sky130_fd_sc_hd__decap_4
X_1034_ _0075_ _0078_ _0291_ _0290_ VGND VGND VPWR VPWR _0365_ sky130_fd_sc_hd__o31a_1
X_1103_ _0390_ _0391_ net236 _0428_ VGND VGND VPWR VPWR _0433_ sky130_fd_sc_hd__o211ai_2
X_0818_ _0167_ _0169_ _0181_ VGND VGND VPWR VPWR _0182_ sky130_fd_sc_hd__a21boi_4
X_0749_ _0117_ _0120_ _0121_ VGND VGND VPWR VPWR _0122_ sky130_fd_sc_hd__a21oi_1
XFILLER_29_225 VPWR VGND VPWR VGND sky130_ef_sc_hd__decap_12
XFILLER_52_261 VGND VGND VPWR VPWR sky130_fd_sc_hd__fill_1
XFILLER_16_77 VGND VGND VPWR VPWR sky130_fd_sc_hd__decap_6
XFILLER_4_302 VGND VGND VPWR VPWR sky130_fd_sc_hd__fill_2
XFILLER_20_180 VPWR VGND VPWR VGND sky130_ef_sc_hd__decap_12
XTAP_TAPCELL_ROW_7_151 VGND VPWR sky130_fd_sc_hd__tapvpwrvgnd_1
XFILLER_35_217 VGND VGND VPWR VPWR sky130_fd_sc_hd__decap_6
XTAP_TAPCELL_ROW_13_186 VGND VPWR sky130_fd_sc_hd__tapvpwrvgnd_1
XFILLER_7_162 VGND VGND VPWR VPWR sky130_fd_sc_hd__fill_1
XFILLER_26_217 VPWR VGND VPWR VGND sky130_ef_sc_hd__decap_12
X_1017_ _0342_ _0343_ net111 net116 VGND VGND VPWR VPWR _0348_ sky130_fd_sc_hd__and4_1
XFILLER_1_305 VGND VGND VPWR VPWR sky130_fd_sc_hd__decap_6
XFILLER_43_53 VGND VGND VPWR VPWR sky130_fd_sc_hd__decap_3
XFILLER_40_253 VPWR VGND VPWR VGND sky130_ef_sc_hd__decap_12
XTAP_TAPCELL_ROW_10_167 VGND VPWR sky130_fd_sc_hd__tapvpwrvgnd_1
XTAP_TAPCELL_ROW_18_212 VGND VPWR sky130_fd_sc_hd__tapvpwrvgnd_1
XTAP_TAPCELL_ROW_49_381 VGND VPWR sky130_fd_sc_hd__tapvpwrvgnd_1
XTAP_TAPCELL_ROW_32_292 VGND VPWR sky130_fd_sc_hd__tapvpwrvgnd_1
Xfanout79 net80 VGND VGND VPWR VPWR net79 sky130_fd_sc_hd__clkbuf_4
XFILLER_13_23 VGND VGND VPWR VPWR sky130_fd_sc_hd__decap_3
XTAP_TAPCELL_ROW_24_248 VGND VPWR sky130_fd_sc_hd__tapvpwrvgnd_1
XFILLER_1_113 VGND VGND VPWR VPWR sky130_fd_sc_hd__decap_3
XFILLER_38_97 VPWR VGND VPWR VGND sky130_ef_sc_hd__decap_12
X_1351_ _0648_ _0666_ _0665_ VGND VGND VPWR VPWR _0674_ sky130_fd_sc_hd__a21oi_2
X_1420_ clknet_3_2__leaf_clk _0046_ VGND VGND VPWR VPWR product_reg\[3\] sky130_fd_sc_hd__dfxtp_1
X_1282_ _0606_ _0607_ _0076_ net87 VGND VGND VPWR VPWR _0608_ sky130_fd_sc_hd__o2bb2ai_2
XTAP_TAPCELL_ROW_21_229 VGND VPWR sky130_fd_sc_hd__tapvpwrvgnd_1
X_0997_ net89 net223 net100 net129 VGND VGND VPWR VPWR _0328_ sky130_fd_sc_hd__a22o_4
XFILLER_39_161 VGND VGND VPWR VPWR sky130_fd_sc_hd__decap_6
XTAP_TAPCELL_ROW_52_398 VGND VPWR sky130_fd_sc_hd__tapvpwrvgnd_1
XFILLER_10_267 VGND VGND VPWR VPWR sky130_fd_sc_hd__fill_2
XFILLER_24_44 VGND VGND VPWR VPWR sky130_fd_sc_hd__decap_3
XFILLER_49_30 VGND VGND VPWR VPWR sky130_fd_sc_hd__decap_6
XFILLER_1_15 VPWR VGND VPWR VGND sky130_ef_sc_hd__decap_12
X_0920_ _0250_ _0251_ _0252_ VGND VGND VPWR VPWR _0254_ sky130_fd_sc_hd__a21o_1
X_0782_ _0148_ _0149_ _0150_ net83 VGND VGND VPWR VPWR _0010_ sky130_fd_sc_hd__o211a_1
X_0851_ net50 net49 VGND VGND VPWR VPWR _0208_ sky130_fd_sc_hd__nand2_1
X_1334_ _0077_ net87 _0635_ _0611_ _0079_ VGND VGND VPWR VPWR _0658_ sky130_fd_sc_hd__o32ai_2
X_1403_ clknet_3_7__leaf_clk _0029_ VGND VGND VPWR VPWR net57 sky130_fd_sc_hd__dfxtp_1
X_1265_ _0588_ _0589_ _0590_ VGND VGND VPWR VPWR _0592_ sky130_fd_sc_hd__a21o_1
XPHY_EDGE_ROW_18_Right_18 VGND VGND VPWR VPWR sky130_fd_sc_hd__decap_3
X_1196_ net101 net117 VGND VGND VPWR VPWR _0524_ sky130_fd_sc_hd__nand2_1
Xinput3 a_in[2] VGND VGND VPWR VPWR net3 sky130_fd_sc_hd__clkbuf_1
XPHY_EDGE_ROW_27_Right_27 VGND VGND VPWR VPWR sky130_fd_sc_hd__decap_3
XPHY_EDGE_ROW_36_Right_36 VGND VGND VPWR VPWR sky130_fd_sc_hd__decap_3
XPHY_EDGE_ROW_45_Right_45 VGND VGND VPWR VPWR sky130_fd_sc_hd__decap_3
XTAP_TAPCELL_ROW_40_335 VGND VPWR sky130_fd_sc_hd__tapvpwrvgnd_1
XFILLER_51_86 VPWR VGND VPWR VGND sky130_ef_sc_hd__decap_12
X_1050_ _0353_ _0355_ _0357_ _0368_ VGND VGND VPWR VPWR _0380_ sky130_fd_sc_hd__a31oi_2
XFILLER_18_197 VPWR VGND VPWR VGND sky130_ef_sc_hd__decap_12
X_0834_ net149 _0195_ _0193_ VGND VGND VPWR VPWR _0196_ sky130_fd_sc_hd__o21a_4
X_0903_ net89 net106 net109 net311 VGND VGND VPWR VPWR _0238_ sky130_fd_sc_hd__a22oi_1
X_0696_ net101 VGND VGND VPWR VPWR _0076_ sky130_fd_sc_hd__clkinv_4
X_0765_ _0131_ _0133_ _0134_ VGND VGND VPWR VPWR _0136_ sky130_fd_sc_hd__o21ai_1
X_1317_ _0638_ _0639_ _0614_ _0609_ VGND VGND VPWR VPWR _0642_ sky130_fd_sc_hd__a22o_1
X_1248_ _0573_ net113 net105 _0572_ VGND VGND VPWR VPWR _0575_ sky130_fd_sc_hd__nand4_2
X_1179_ _0075_ net354 net390 _0363_ _0437_ VGND VGND VPWR VPWR _0508_ sky130_fd_sc_hd__o41ai_4
XFILLER_24_178 VGND VGND VPWR VPWR sky130_fd_sc_hd__fill_2
XFILLER_47_237 VPWR VGND VPWR VGND sky130_ef_sc_hd__decap_12
XFILLER_38_248 VGND VGND VPWR VPWR sky130_fd_sc_hd__decap_4
X_1102_ _0390_ _0391_ _0427_ _0429_ VGND VGND VPWR VPWR _0432_ sky130_fd_sc_hd__o22ai_2
X_1033_ _0292_ net118 net132 net306 VGND VGND VPWR VPWR _0364_ sky130_fd_sc_hd__a31o_1
X_0817_ _0165_ _0173_ _0175_ VGND VGND VPWR VPWR _0181_ sky130_fd_sc_hd__and3_1
X_0748_ _0117_ _0120_ net75 VGND VGND VPWR VPWR _0121_ sky130_fd_sc_hd__o21ai_1
XFILLER_44_218 VPWR VGND VPWR VGND sky130_ef_sc_hd__decap_12
XFILLER_29_237 VGND VGND VPWR VPWR sky130_fd_sc_hd__fill_1
XFILLER_52_251 VGND VGND VPWR VPWR sky130_fd_sc_hd__fill_1
XPHY_EDGE_ROW_0_Right_0 VGND VGND VPWR VPWR sky130_fd_sc_hd__decap_3
XFILLER_12_137 VGND VGND VPWR VPWR sky130_fd_sc_hd__decap_3
XFILLER_12_148 VPWR VGND VPWR VGND sky130_ef_sc_hd__decap_12
XFILLER_16_45 VPWR VGND VPWR VGND sky130_ef_sc_hd__decap_12
XFILLER_32_66 VGND VGND VPWR VPWR sky130_fd_sc_hd__fill_1
XFILLER_20_192 VGND VGND VPWR VPWR sky130_fd_sc_hd__decap_4
XTAP_TAPCELL_ROW_7_152 VGND VPWR sky130_fd_sc_hd__tapvpwrvgnd_1
XTAP_TAPCELL_ROW_13_187 VGND VPWR sky130_fd_sc_hd__tapvpwrvgnd_1
XFILLER_19_281 VGND VGND VPWR VPWR sky130_fd_sc_hd__fill_1
XFILLER_26_229 VPWR VGND VPWR VGND sky130_ef_sc_hd__decap_12
XFILLER_34_251 VGND VGND VPWR VPWR sky130_fd_sc_hd__fill_1
X_1016_ net105 net107 net125 net122 _0340_ VGND VGND VPWR VPWR _0347_ sky130_fd_sc_hd__a41o_1
XTAP_TAPCELL_ROW_4_133 VGND VPWR sky130_fd_sc_hd__tapvpwrvgnd_1
XFILLER_27_99 VGND VGND VPWR VPWR sky130_fd_sc_hd__fill_2
XFILLER_40_265 VPWR VGND VPWR VGND sky130_ef_sc_hd__decap_12
XFILLER_4_111 VGND VGND VPWR VPWR sky130_fd_sc_hd__fill_2
XFILLER_4_15 VPWR VGND VPWR VGND sky130_ef_sc_hd__decap_12
XTAP_TAPCELL_ROW_10_168 VGND VPWR sky130_fd_sc_hd__tapvpwrvgnd_1
XTAP_TAPCELL_ROW_18_213 VGND VPWR sky130_fd_sc_hd__tapvpwrvgnd_1
XFILLER_31_287 VGND VGND VPWR VPWR sky130_fd_sc_hd__fill_1
XTAP_TAPCELL_ROW_49_382 VGND VPWR sky130_fd_sc_hd__tapvpwrvgnd_1
XFILLER_22_210 VGND VGND VPWR VPWR sky130_fd_sc_hd__decap_3
XFILLER_13_57 VGND VGND VPWR VPWR sky130_fd_sc_hd__fill_1
XFILLER_22_221 VPWR VGND VPWR VGND sky130_ef_sc_hd__decap_12
XFILLER_1_169 VGND VGND VPWR VPWR sky130_fd_sc_hd__decap_4
XFILLER_9_225 VGND VGND VPWR VPWR sky130_fd_sc_hd__fill_2
XFILLER_9_258 VPWR VGND VPWR VGND sky130_ef_sc_hd__decap_12
X_1281_ _0605_ net387 net98 _0578_ VGND VGND VPWR VPWR _0607_ sky130_fd_sc_hd__nand4_4
X_1350_ net244 _0654_ _0672_ VGND VGND VPWR VPWR _0673_ sky130_fd_sc_hd__nand3_2
X_0996_ net88 net223 net128 net100 VGND VGND VPWR VPWR _0327_ sky130_fd_sc_hd__a22oi_4
XTAP_TAPCELL_ROW_52_399 VGND VPWR sky130_fd_sc_hd__tapvpwrvgnd_1
XFILLER_10_257 VGND VGND VPWR VPWR sky130_fd_sc_hd__fill_1
XFILLER_6_3 VPWR VGND VPWR VGND sky130_ef_sc_hd__decap_12
XFILLER_33_305 VGND VGND VPWR VPWR sky130_fd_sc_hd__fill_2
XFILLER_1_27 VPWR VGND VPWR VGND sky130_ef_sc_hd__decap_12
X_0850_ net49 net71 _0204_ net50 VGND VGND VPWR VPWR _0207_ sky130_fd_sc_hd__a31o_1
X_1402_ clknet_3_7__leaf_clk _0028_ VGND VGND VPWR VPWR net56 sky130_fd_sc_hd__dfxtp_1
X_0781_ net76 net68 VGND VGND VPWR VPWR _0150_ sky130_fd_sc_hd__or2_1
Xinput4 a_in[3] VGND VGND VPWR VPWR net4 sky130_fd_sc_hd__clkbuf_1
X_1333_ net389 _0232_ _0657_ _0086_ VGND VGND VPWR VPWR _0055_ sky130_fd_sc_hd__o2bb2ai_1
X_1264_ _0588_ _0589_ _0590_ VGND VGND VPWR VPWR _0591_ sky130_fd_sc_hd__a21oi_1
XFILLER_51_113 VGND VGND VPWR VPWR sky130_fd_sc_hd__decap_4
X_1195_ _0329_ net92 net11 VGND VGND VPWR VPWR _0523_ sky130_fd_sc_hd__and3_1
XFILLER_36_176 VGND VGND VPWR VPWR sky130_fd_sc_hd__decap_6
XTAP_TAPCELL_ROW_34_300 VGND VPWR sky130_fd_sc_hd__tapvpwrvgnd_1
X_0979_ _0307_ _0309_ _0295_ VGND VGND VPWR VPWR _0311_ sky130_fd_sc_hd__nand3b_1
XFILLER_50_190 VGND VGND VPWR VPWR sky130_fd_sc_hd__fill_1
XFILLER_42_135 VGND VGND VPWR VPWR sky130_fd_sc_hd__decap_4
XTAP_TAPCELL_ROW_40_336 VGND VPWR sky130_fd_sc_hd__tapvpwrvgnd_1
XFILLER_51_98 VPWR VGND VPWR VGND sky130_ef_sc_hd__decap_12
X_0833_ product_reg\[15\] net43 _0183_ _0194_ VGND VGND VPWR VPWR _0195_ sky130_fd_sc_hd__a211o_1
X_0902_ net89 net310 net106 net109 VGND VGND VPWR VPWR _0237_ sky130_fd_sc_hd__and4_1
X_0695_ net131 VGND VGND VPWR VPWR _0075_ sky130_fd_sc_hd__inv_2
X_0764_ _0131_ _0133_ _0134_ VGND VGND VPWR VPWR _0135_ sky130_fd_sc_hd__or3_1
X_1316_ _0614_ _0638_ _0639_ _0609_ VGND VGND VPWR VPWR _0641_ sky130_fd_sc_hd__nand4_1
X_1247_ net105 net113 _0572_ _0573_ VGND VGND VPWR VPWR _0574_ sky130_fd_sc_hd__a22o_1
X_1178_ _0384_ _0502_ _0494_ _0499_ _0498_ VGND VGND VPWR VPWR _0507_ sky130_fd_sc_hd__o221ai_4
XFILLER_21_57 VGND VGND VPWR VPWR sky130_fd_sc_hd__decap_6
XFILLER_47_249 VPWR VGND VPWR VGND sky130_ef_sc_hd__decap_12
XFILLER_7_15 VPWR VGND VPWR VGND sky130_ef_sc_hd__decap_12
X_1032_ _0075_ _0078_ _0290_ VGND VGND VPWR VPWR _0363_ sky130_fd_sc_hd__o21a_1
X_1101_ _0388_ _0389_ _0428_ net236 VGND VGND VPWR VPWR _0431_ sky130_fd_sc_hd__o211ai_4
XFILLER_46_293 VGND VGND VPWR VPWR sky130_fd_sc_hd__decap_8
XFILLER_21_105 VGND VGND VPWR VPWR sky130_fd_sc_hd__decap_4
XFILLER_21_138 VGND VGND VPWR VPWR sky130_fd_sc_hd__decap_8
X_0816_ product_reg\[14\] net42 VGND VGND VPWR VPWR _0180_ sky130_fd_sc_hd__nand2_1
X_0747_ _0118_ _0119_ VGND VGND VPWR VPWR _0120_ sky130_fd_sc_hd__and2_1
XFILLER_29_216 VGND VGND VPWR VPWR sky130_fd_sc_hd__decap_8
XFILLER_16_57 VGND VGND VPWR VPWR sky130_fd_sc_hd__decap_8
XFILLER_20_160 VPWR VGND VPWR VGND sky130_ef_sc_hd__decap_12
XTAP_TAPCELL_ROW_7_153 VGND VPWR sky130_fd_sc_hd__tapvpwrvgnd_1
XFILLER_21_3 VGND VGND VPWR VPWR sky130_fd_sc_hd__fill_2
X_1015_ _0343_ net116 net111 VGND VGND VPWR VPWR _0346_ sky130_fd_sc_hd__and3_1
XPHY_EDGE_ROW_14_Left_67 VGND VGND VPWR VPWR sky130_fd_sc_hd__decap_3
XTAP_TAPCELL_ROW_4_134 VGND VPWR sky130_fd_sc_hd__tapvpwrvgnd_1
XFILLER_25_241 VGND VGND VPWR VPWR sky130_fd_sc_hd__fill_2
XFILLER_27_67 VPWR VGND VPWR VGND sky130_ef_sc_hd__decap_12
XFILLER_40_288 VGND VGND VPWR VPWR sky130_fd_sc_hd__decap_6
XFILLER_40_277 VGND VGND VPWR VPWR sky130_fd_sc_hd__decap_6
XTAP_TAPCELL_ROW_10_169 VGND VPWR sky130_fd_sc_hd__tapvpwrvgnd_1
XFILLER_4_49 VGND VGND VPWR VPWR sky130_fd_sc_hd__fill_1
XFILLER_4_27 VGND VGND VPWR VPWR sky130_fd_sc_hd__fill_1
XTAP_TAPCELL_ROW_18_214 VGND VPWR sky130_fd_sc_hd__tapvpwrvgnd_1
XFILLER_31_255 VPWR VGND VPWR VGND sky130_ef_sc_hd__decap_12
XFILLER_31_233 VGND VGND VPWR VPWR sky130_fd_sc_hd__decap_3
XFILLER_31_222 VGND VGND VPWR VPWR sky130_fd_sc_hd__fill_2
XFILLER_31_200 VGND VGND VPWR VPWR sky130_fd_sc_hd__fill_2
XTAP_TAPCELL_ROW_49_383 VGND VPWR sky130_fd_sc_hd__tapvpwrvgnd_1
XFILLER_22_233 VGND VGND VPWR VPWR sky130_fd_sc_hd__decap_4
XFILLER_13_36 VGND VGND VPWR VPWR sky130_fd_sc_hd__decap_6
XFILLER_22_277 VGND VGND VPWR VPWR sky130_fd_sc_hd__decap_3
XFILLER_22_288 VGND VGND VPWR VPWR sky130_fd_sc_hd__fill_2
XFILLER_38_66 VGND VGND VPWR VPWR sky130_fd_sc_hd__fill_1
XFILLER_13_222 VGND VGND VPWR VPWR sky130_fd_sc_hd__fill_2
XFILLER_48_141 VGND VGND VPWR VPWR sky130_fd_sc_hd__fill_2
X_1280_ _0077_ _0079_ _0576_ _0577_ _0579_ VGND VGND VPWR VPWR _0606_ sky130_fd_sc_hd__o221ai_4
XFILLER_48_174 VGND VGND VPWR VPWR sky130_fd_sc_hd__fill_2
XTAP_TAPCELL_ROW_46_364 VGND VPWR sky130_fd_sc_hd__tapvpwrvgnd_1
X_0995_ net126 net102 VGND VGND VPWR VPWR _0326_ sky130_fd_sc_hd__nand2_2
XPHY_EDGE_ROW_17_Left_70 VGND VGND VPWR VPWR sky130_fd_sc_hd__decap_3
XFILLER_49_76 VGND VGND VPWR VPWR sky130_fd_sc_hd__fill_1
XFILLER_45_111 VGND VGND VPWR VPWR sky130_fd_sc_hd__fill_1
XFILLER_1_39 VPWR VGND VPWR VGND sky130_ef_sc_hd__decap_12
X_0780_ _0145_ _0146_ _0147_ _0070_ VGND VGND VPWR VPWR _0149_ sky130_fd_sc_hd__a31o_1
X_1401_ clknet_3_7__leaf_clk _0027_ VGND VGND VPWR VPWR net55 sky130_fd_sc_hd__dfxtp_1
Xinput5 a_in[4] VGND VGND VPWR VPWR net5 sky130_fd_sc_hd__buf_2
X_1332_ _0655_ _0656_ VGND VGND VPWR VPWR _0657_ sky130_fd_sc_hd__nand2_1
X_1263_ _0546_ _0537_ _0539_ VGND VGND VPWR VPWR _0590_ sky130_fd_sc_hd__o21ai_1
X_1194_ _0488_ _0489_ _0476_ _0475_ VGND VGND VPWR VPWR _0522_ sky130_fd_sc_hd__a2bb2o_1
XFILLER_51_169 VPWR VGND VPWR VGND sky130_ef_sc_hd__decap_12
XTAP_TAPCELL_ROW_34_301 VGND VPWR sky130_fd_sc_hd__tapvpwrvgnd_1
XFILLER_24_306 VGND VGND VPWR VPWR sky130_fd_sc_hd__fill_2
XFILLER_10_15 VPWR VGND VPWR VGND sky130_ef_sc_hd__decap_12
X_0978_ _0307_ _0308_ _0295_ VGND VGND VPWR VPWR _0310_ sky130_fd_sc_hd__o21bai_1
XFILLER_19_46 VGND VGND VPWR VPWR sky130_fd_sc_hd__decap_4
XFILLER_35_34 VGND VGND VPWR VPWR sky130_fd_sc_hd__decap_8
XFILLER_19_57 VGND VGND VPWR VPWR sky130_fd_sc_hd__decap_3
XFILLER_27_111 VGND VGND VPWR VPWR sky130_fd_sc_hd__fill_1
XFILLER_51_77 VGND VGND VPWR VPWR sky130_fd_sc_hd__decap_3
XFILLER_51_55 VGND VGND VPWR VPWR sky130_fd_sc_hd__fill_1
XFILLER_30_309 VGND VGND VPWR VPWR sky130_fd_sc_hd__fill_2
XPHY_EDGE_ROW_2_Left_55 VGND VGND VPWR VPWR sky130_fd_sc_hd__decap_3
XFILLER_33_158 VGND VGND VPWR VPWR sky130_fd_sc_hd__fill_2
X_0832_ _0187_ net42 product_reg\[14\] VGND VGND VPWR VPWR _0194_ sky130_fd_sc_hd__and3_1
X_0901_ net393 net82 _0085_ _0236_ VGND VGND VPWR VPWR _0044_ sky130_fd_sc_hd__a31o_1
X_0763_ _0119_ net178 _0125_ product_reg\[6\] net65 VGND VGND VPWR VPWR _0134_ sky130_fd_sc_hd__a32o_1
XFILLER_51_3 VPWR VGND VPWR VGND sky130_ef_sc_hd__decap_12
X_1315_ _0615_ _0638_ _0639_ VGND VGND VPWR VPWR _0640_ sky130_fd_sc_hd__and3_1
X_0694_ net126 VGND VGND VPWR VPWR _0074_ sky130_fd_sc_hd__clkinv_4
X_1246_ _0571_ net115 net5 _0526_ VGND VGND VPWR VPWR _0573_ sky130_fd_sc_hd__nand4_1
X_1177_ _0384_ _0502_ _0494_ _0499_ _0498_ VGND VGND VPWR VPWR _0506_ sky130_fd_sc_hd__o221a_4
XPHY_EDGE_ROW_44_Left_97 VGND VGND VPWR VPWR sky130_fd_sc_hd__decap_3
XFILLER_32_180 VGND VGND VPWR VPWR sky130_fd_sc_hd__decap_3
XFILLER_12_309 VGND VGND VPWR VPWR sky130_fd_sc_hd__fill_2
XFILLER_15_169 VGND VGND VPWR VPWR sky130_fd_sc_hd__decap_8
XFILLER_30_139 VGND VGND VPWR VPWR sky130_fd_sc_hd__fill_1
XFILLER_7_27 VGND VGND VPWR VPWR sky130_fd_sc_hd__fill_1
XFILLER_46_261 VGND VGND VPWR VPWR sky130_fd_sc_hd__decap_3
X_1031_ net132 net114 VGND VGND VPWR VPWR _0362_ sky130_fd_sc_hd__nand2_1
X_1100_ _0325_ _0336_ _0420_ _0354_ _0421_ VGND VGND VPWR VPWR _0430_ sky130_fd_sc_hd__o2111ai_4
X_0815_ product_reg\[14\] net42 VGND VGND VPWR VPWR _0179_ sky130_fd_sc_hd__or2_1
X_0746_ product_reg\[5\] net64 VGND VGND VPWR VPWR _0119_ sky130_fd_sc_hd__or2_1
XFILLER_52_253 VGND VGND VPWR VPWR sky130_fd_sc_hd__decap_8
X_1229_ _0387_ _0501_ _0500_ VGND VGND VPWR VPWR _0557_ sky130_fd_sc_hd__o21ai_4
XFILLER_20_172 VGND VGND VPWR VPWR sky130_fd_sc_hd__decap_4
XTAP_TAPCELL_ROW_7_154 VGND VPWR sky130_fd_sc_hd__tapvpwrvgnd_1
XFILLER_28_250 VGND VGND VPWR VPWR sky130_fd_sc_hd__fill_2
XFILLER_11_150 VPWR VGND VPWR VGND sky130_ef_sc_hd__decap_12
XFILLER_7_154 VGND VGND VPWR VPWR sky130_fd_sc_hd__decap_8
XFILLER_14_3 VPWR VGND VPWR VGND sky130_ef_sc_hd__decap_12
XFILLER_34_231 VPWR VGND VPWR VGND sky130_ef_sc_hd__decap_12
X_1014_ net111 net116 _0342_ _0343_ VGND VGND VPWR VPWR _0345_ sky130_fd_sc_hd__a22o_1
X_0729_ product_reg\[3\] net62 VGND VGND VPWR VPWR _0104_ sky130_fd_sc_hd__and2_1
XTAP_TAPCELL_ROW_4_135 VGND VPWR sky130_fd_sc_hd__tapvpwrvgnd_1
XFILLER_43_45 VGND VGND VPWR VPWR sky130_fd_sc_hd__decap_8
XFILLER_25_264 VPWR VGND VPWR VGND sky130_ef_sc_hd__decap_12
XFILLER_27_79 VPWR VGND VPWR VGND sky130_ef_sc_hd__decap_12
XPHY_EDGE_ROW_31_Left_84 VGND VGND VPWR VPWR sky130_fd_sc_hd__decap_3
XTAP_TAPCELL_ROW_18_215 VGND VPWR sky130_fd_sc_hd__tapvpwrvgnd_1
XFILLER_31_267 VPWR VGND VPWR VGND sky130_ef_sc_hd__decap_12
XFILLER_3_190 VGND VGND VPWR VPWR sky130_fd_sc_hd__decap_3
XTAP_TAPCELL_ROW_49_384 VGND VPWR sky130_fd_sc_hd__tapvpwrvgnd_1
XFILLER_13_15 VGND VGND VPWR VPWR sky130_fd_sc_hd__decap_8
XFILLER_1_105 VGND VGND VPWR VPWR sky130_fd_sc_hd__decap_6
XFILLER_9_205 VPWR VGND VPWR VGND sky130_ef_sc_hd__decap_12
XFILLER_13_278 VGND VGND VPWR VPWR sky130_fd_sc_hd__fill_2
XTAP_TAPCELL_ROW_23_240 VGND VPWR sky130_fd_sc_hd__tapvpwrvgnd_1
XFILLER_0_182 VGND VGND VPWR VPWR sky130_fd_sc_hd__decap_3
XTAP_TAPCELL_ROW_46_365 VGND VPWR sky130_fd_sc_hd__tapvpwrvgnd_1
X_0994_ _0299_ _0300_ _0303_ VGND VGND VPWR VPWR _0325_ sky130_fd_sc_hd__o21a_4
XTAP_TAPCELL_ROW_20_221 VGND VPWR sky130_fd_sc_hd__tapvpwrvgnd_1
XFILLER_24_36 VGND VGND VPWR VPWR sky130_fd_sc_hd__decap_8
Xhold260 product_reg\[3\] VGND VGND VPWR VPWR net392 sky130_fd_sc_hd__dlygate4sd3_1
XFILLER_45_156 VPWR VGND VPWR VGND sky130_ef_sc_hd__decap_12
X_1331_ _0654_ net239 _0648_ _0647_ VGND VGND VPWR VPWR _0656_ sky130_fd_sc_hd__o2bb2ai_1
X_1400_ clknet_3_6__leaf_clk _0026_ VGND VGND VPWR VPWR net54 sky130_fd_sc_hd__dfxtp_1
Xinput6 a_in[5] VGND VGND VPWR VPWR net6 sky130_fd_sc_hd__buf_1
X_1262_ _0574_ _0575_ _0585_ _0586_ VGND VGND VPWR VPWR _0589_ sky130_fd_sc_hd__a22o_1
XFILLER_36_145 VGND VGND VPWR VPWR sky130_fd_sc_hd__fill_2
XFILLER_36_134 VGND VGND VPWR VPWR sky130_fd_sc_hd__decap_6
X_1193_ _0488_ _0489_ net137 _0475_ VGND VGND VPWR VPWR _0521_ sky130_fd_sc_hd__a2bb2oi_1
XFILLER_51_126 VPWR VGND VPWR VGND sky130_ef_sc_hd__decap_12
XTAP_TAPCELL_ROW_34_302 VGND VPWR sky130_fd_sc_hd__tapvpwrvgnd_1
XFILLER_10_27 VGND VGND VPWR VPWR sky130_fd_sc_hd__fill_1
XFILLER_10_49 VGND VGND VPWR VPWR sky130_fd_sc_hd__decap_3
X_0977_ _0266_ _0296_ _0304_ _0305_ VGND VGND VPWR VPWR _0309_ sky130_fd_sc_hd__nand4_2
XFILLER_19_69 VGND VGND VPWR VPWR sky130_fd_sc_hd__fill_1
XFILLER_35_57 VGND VGND VPWR VPWR sky130_fd_sc_hd__decap_4
XPHY_EDGE_ROW_14_Right_14 VGND VGND VPWR VPWR sky130_fd_sc_hd__decap_3
Xclkbuf_3_3__f_clk clknet_0_clk VGND VGND VPWR VPWR clknet_3_3__leaf_clk sky130_fd_sc_hd__clkbuf_16
XPHY_EDGE_ROW_23_Right_23 VGND VGND VPWR VPWR sky130_fd_sc_hd__decap_3
XPHY_EDGE_ROW_32_Right_32 VGND VGND VPWR VPWR sky130_fd_sc_hd__decap_3
X_0900_ _0000_ net331 net334 VGND VGND VPWR VPWR _0236_ sky130_fd_sc_hd__and3_1
XFILLER_25_90 VGND VGND VPWR VPWR sky130_fd_sc_hd__decap_4
X_0831_ product_reg\[15\] net43 _0192_ VGND VGND VPWR VPWR _0193_ sky130_fd_sc_hd__o21a_1
X_0693_ net103 VGND VGND VPWR VPWR _0073_ sky130_fd_sc_hd__inv_2
X_0762_ _0068_ _0071_ VGND VGND VPWR VPWR _0133_ sky130_fd_sc_hd__nor2_1
X_1314_ _0636_ _0637_ _0610_ VGND VGND VPWR VPWR _0639_ sky130_fd_sc_hd__a21o_1
XPHY_EDGE_ROW_41_Right_41 VGND VGND VPWR VPWR sky130_fd_sc_hd__decap_3
XPHY_EDGE_ROW_50_Right_50 VGND VGND VPWR VPWR sky130_fd_sc_hd__decap_3
XFILLER_49_281 VGND VGND VPWR VPWR sky130_fd_sc_hd__decap_3
XFILLER_49_270 VGND VGND VPWR VPWR sky130_fd_sc_hd__fill_2
X_1245_ _0076_ _0079_ _0524_ _0525_ _0529_ VGND VGND VPWR VPWR _0572_ sky130_fd_sc_hd__o221ai_4
XFILLER_2_83 VGND VGND VPWR VPWR sky130_fd_sc_hd__fill_1
X_1176_ net216 _0500_ _0501_ _0387_ VGND VGND VPWR VPWR _0505_ sky130_fd_sc_hd__o2bb2ai_4
XFILLER_24_104 VGND VGND VPWR VPWR sky130_fd_sc_hd__decap_6
XFILLER_47_207 VPWR VGND VPWR VGND sky130_ef_sc_hd__decap_12
XFILLER_46_12 VPWR VGND VPWR VGND sky130_ef_sc_hd__decap_12
XFILLER_46_251 VGND VGND VPWR VPWR sky130_fd_sc_hd__fill_1
X_1030_ _0338_ _0354_ _0357_ _0353_ VGND VGND VPWR VPWR _0361_ sky130_fd_sc_hd__o211ai_4
Xinput20 net318 VGND VGND VPWR VPWR net20 sky130_fd_sc_hd__clkbuf_2
X_0814_ net77 net371 net84 _0178_ VGND VGND VPWR VPWR _0014_ sky130_fd_sc_hd__o211a_1
XFILLER_14_170 VGND VGND VPWR VPWR sky130_fd_sc_hd__decap_8
X_0745_ product_reg\[5\] net64 VGND VGND VPWR VPWR _0118_ sky130_fd_sc_hd__nand2_1
X_1228_ _0485_ _0518_ _0553_ _0551_ VGND VGND VPWR VPWR _0556_ sky130_fd_sc_hd__o22ai_4
XFILLER_52_221 VGND VGND VPWR VPWR sky130_fd_sc_hd__decap_3
XFILLER_12_129 VGND VGND VPWR VPWR sky130_fd_sc_hd__fill_1
XFILLER_16_26 VGND VGND VPWR VPWR sky130_fd_sc_hd__fill_2
X_1159_ _0480_ _0483_ _0484_ VGND VGND VPWR VPWR _0488_ sky130_fd_sc_hd__and3_1
XFILLER_43_221 VGND VGND VPWR VPWR sky130_fd_sc_hd__decap_3
XFILLER_11_162 VGND VGND VPWR VPWR sky130_fd_sc_hd__decap_6
XFILLER_34_243 VGND VGND VPWR VPWR sky130_fd_sc_hd__decap_8
X_1013_ net111 net116 _0342_ _0343_ VGND VGND VPWR VPWR _0344_ sky130_fd_sc_hd__a22oi_4
XFILLER_8_93 VGND VGND VPWR VPWR sky130_fd_sc_hd__decap_6
XPHY_EDGE_ROW_4_Right_4 VGND VGND VPWR VPWR sky130_fd_sc_hd__decap_3
X_0728_ _0098_ _0096_ _0089_ _0095_ VGND VGND VPWR VPWR _0103_ sky130_fd_sc_hd__o31ai_4
XTAP_TAPCELL_ROW_4_136 VGND VPWR sky130_fd_sc_hd__tapvpwrvgnd_1
XFILLER_27_36 VGND VGND VPWR VPWR sky130_fd_sc_hd__decap_6
XFILLER_43_79 VGND VGND VPWR VPWR sky130_fd_sc_hd__fill_1
XFILLER_43_24 VGND VGND VPWR VPWR sky130_fd_sc_hd__fill_2
XFILLER_25_276 VGND VGND VPWR VPWR sky130_fd_sc_hd__decap_4
XFILLER_4_147 VGND VGND VPWR VPWR sky130_fd_sc_hd__decap_6
XFILLER_4_29 VPWR VGND VPWR VGND sky130_ef_sc_hd__decap_12
XFILLER_31_279 VGND VGND VPWR VPWR sky130_fd_sc_hd__fill_1
XTAP_TAPCELL_ROW_49_385 VGND VPWR sky130_fd_sc_hd__tapvpwrvgnd_1
XTAP_TAPCELL_ROW_1_117 VGND VPWR sky130_fd_sc_hd__tapvpwrvgnd_1
XFILLER_22_257 VPWR VGND VPWR VGND sky130_ef_sc_hd__decap_12
XFILLER_45_305 VGND VGND VPWR VPWR sky130_fd_sc_hd__decap_6
XFILLER_9_217 VGND VGND VPWR VPWR sky130_fd_sc_hd__decap_6
XTAP_TAPCELL_ROW_23_241 VGND VPWR sky130_fd_sc_hd__tapvpwrvgnd_1
XFILLER_0_161 VGND VGND VPWR VPWR sky130_fd_sc_hd__decap_3
XTAP_TAPCELL_ROW_46_366 VGND VPWR sky130_fd_sc_hd__tapvpwrvgnd_1
X_0993_ _0299_ _0300_ VGND VGND VPWR VPWR _0324_ sky130_fd_sc_hd__nor2_2
XFILLER_39_110 VGND VGND VPWR VPWR sky130_fd_sc_hd__fill_2
XTAP_TAPCELL_ROW_20_222 VGND VPWR sky130_fd_sc_hd__tapvpwrvgnd_1
Xhold250 net51 VGND VGND VPWR VPWR net382 sky130_fd_sc_hd__dlygate4sd3_1
Xhold261 product_reg\[1\] VGND VGND VPWR VPWR net393 sky130_fd_sc_hd__dlygate4sd3_1
XFILLER_18_305 VGND VGND VPWR VPWR sky130_fd_sc_hd__decap_3
XFILLER_5_253 VPWR VGND VPWR VGND sky130_ef_sc_hd__decap_12
XFILLER_14_81 VGND VGND VPWR VPWR sky130_fd_sc_hd__decap_3
X_1261_ _0574_ _0575_ _0585_ _0586_ VGND VGND VPWR VPWR _0588_ sky130_fd_sc_hd__nand4_4
XFILLER_39_6 VGND VGND VPWR VPWR sky130_fd_sc_hd__fill_1
X_1330_ _0653_ _0654_ _0650_ VGND VGND VPWR VPWR _0655_ sky130_fd_sc_hd__nand3_4
Xinput7 a_in[6] VGND VGND VPWR VPWR net7 sky130_fd_sc_hd__buf_6
XTAP_TAPCELL_ROW_34_303 VGND VPWR sky130_fd_sc_hd__tapvpwrvgnd_1
X_1192_ _0519_ VGND VGND VPWR VPWR _0520_ sky130_fd_sc_hd__inv_2
XFILLER_51_138 VGND VGND VPWR VPWR sky130_fd_sc_hd__decap_3
X_0976_ _0304_ _0297_ _0305_ VGND VGND VPWR VPWR _0308_ sky130_fd_sc_hd__and3_4
XFILLER_27_113 VGND VGND VPWR VPWR sky130_fd_sc_hd__decap_6
XFILLER_51_57 VPWR VGND VPWR VGND sky130_ef_sc_hd__decap_12
XFILLER_4_3 VPWR VGND VPWR VGND sky130_ef_sc_hd__decap_12
X_0830_ product_reg\[15\] net43 net42 product_reg\[14\] VGND VGND VPWR VPWR _0192_
+ sky130_fd_sc_hd__a211o_1
XFILLER_41_160 VGND VGND VPWR VPWR sky130_fd_sc_hd__decap_3
XFILLER_33_138 VPWR VGND VPWR VGND sky130_ef_sc_hd__decap_12
X_0692_ net64 VGND VGND VPWR VPWR _0072_ sky130_fd_sc_hd__inv_2
X_0761_ product_reg\[7\] net66 VGND VGND VPWR VPWR _0132_ sky130_fd_sc_hd__or2_1
X_1313_ _0078_ _0080_ _0636_ _0637_ VGND VGND VPWR VPWR _0638_ sky130_fd_sc_hd__o211ai_2
X_1244_ _0076_ _0078_ _0529_ VGND VGND VPWR VPWR _0571_ sky130_fd_sc_hd__o21ai_1
XFILLER_37_3 VGND VGND VPWR VPWR sky130_fd_sc_hd__fill_2
X_1175_ net141 _0500_ _0503_ VGND VGND VPWR VPWR _0504_ sky130_fd_sc_hd__a21oi_4
X_0959_ net108 net123 net119 net110 VGND VGND VPWR VPWR _0291_ sky130_fd_sc_hd__a22oi_4
XFILLER_47_219 VGND VGND VPWR VPWR sky130_fd_sc_hd__decap_4
XFILLER_46_24 VGND VGND VPWR VPWR sky130_fd_sc_hd__decap_4
Xclone147 net72 VGND VGND VPWR VPWR net279 sky130_fd_sc_hd__buf_8
Xinput10 b_in[1] VGND VGND VPWR VPWR net10 sky130_fd_sc_hd__buf_8
X_0813_ _0177_ net77 _0176_ VGND VGND VPWR VPWR _0178_ sky130_fd_sc_hd__nand3b_4
XTAP_TAPCELL_ROW_16_199 VGND VPWR sky130_fd_sc_hd__tapvpwrvgnd_1
X_0744_ _0113_ net182 _0111_ VGND VGND VPWR VPWR _0117_ sky130_fd_sc_hd__o21a_1
XFILLER_37_274 VGND VGND VPWR VPWR sky130_fd_sc_hd__decap_6
X_1227_ _0554_ _0552_ VGND VGND VPWR VPWR _0555_ sky130_fd_sc_hd__nand2_2
X_1158_ _0483_ _0484_ net111 net112 VGND VGND VPWR VPWR _0487_ sky130_fd_sc_hd__and4_2
XFILLER_52_266 VGND VGND VPWR VPWR sky130_fd_sc_hd__fill_2
XFILLER_32_15 VPWR VGND VPWR VGND sky130_ef_sc_hd__decap_12
X_1089_ _0414_ _0416_ VGND VGND VPWR VPWR _0419_ sky130_fd_sc_hd__nand2_1
XFILLER_16_38 VGND VGND VPWR VPWR sky130_fd_sc_hd__fill_1
XFILLER_43_233 VGND VGND VPWR VPWR sky130_fd_sc_hd__fill_2
XFILLER_22_70 VGND VGND VPWR VPWR sky130_fd_sc_hd__fill_2
X_1012_ net105 net106 net125 net122 VGND VGND VPWR VPWR _0343_ sky130_fd_sc_hd__nand4_4
X_0727_ net75 net378 net82 _0102_ VGND VGND VPWR VPWR _0003_ sky130_fd_sc_hd__o211a_1
XTAP_TAPCELL_ROW_12_180 VGND VPWR sky130_fd_sc_hd__tapvpwrvgnd_1
XTAP_TAPCELL_ROW_4_137 VGND VPWR sky130_fd_sc_hd__tapvpwrvgnd_1
XFILLER_25_233 VGND VGND VPWR VPWR sky130_fd_sc_hd__decap_8
XFILLER_25_299 VGND VGND VPWR VPWR sky130_fd_sc_hd__fill_1
XFILLER_48_303 VGND VGND VPWR VPWR sky130_fd_sc_hd__fill_1
XFILLER_31_225 VGND VGND VPWR VPWR sky130_fd_sc_hd__decap_8
XFILLER_31_214 VGND VGND VPWR VPWR sky130_fd_sc_hd__decap_8
XFILLER_16_244 VGND VGND VPWR VPWR sky130_fd_sc_hd__fill_1
XTAP_TAPCELL_ROW_1_118 VGND VPWR sky130_fd_sc_hd__tapvpwrvgnd_1
XFILLER_22_269 VGND VGND VPWR VPWR sky130_fd_sc_hd__decap_8
XFILLER_13_225 VPWR VGND VPWR VGND sky130_ef_sc_hd__decap_12
XTAP_TAPCELL_ROW_23_242 VGND VPWR sky130_fd_sc_hd__tapvpwrvgnd_1
XFILLER_51_309 VGND VGND VPWR VPWR sky130_fd_sc_hd__fill_2
XFILLER_0_195 VGND VGND VPWR VPWR sky130_fd_sc_hd__fill_1
XTAP_TAPCELL_ROW_46_367 VGND VPWR sky130_fd_sc_hd__tapvpwrvgnd_1
XFILLER_44_90 VGND VGND VPWR VPWR sky130_fd_sc_hd__decap_3
X_0992_ _0316_ _0275_ _0314_ VGND VGND VPWR VPWR _0323_ sky130_fd_sc_hd__a21o_1
XFILLER_8_251 VGND VGND VPWR VPWR sky130_fd_sc_hd__fill_1
XFILLER_42_309 VGND VGND VPWR VPWR sky130_fd_sc_hd__fill_2
XFILLER_40_48 VGND VGND VPWR VPWR sky130_fd_sc_hd__fill_1
XFILLER_10_206 VPWR VGND VPWR VGND sky130_ef_sc_hd__decap_12
XTAP_TAPCELL_ROW_20_223 VGND VPWR sky130_fd_sc_hd__tapvpwrvgnd_1
Xhold262 net55 VGND VGND VPWR VPWR net394 sky130_fd_sc_hd__dlygate4sd3_1
Xhold240 product_reg\[0\] VGND VGND VPWR VPWR net372 sky130_fd_sc_hd__dlygate4sd3_1
Xhold251 net47 VGND VGND VPWR VPWR net383 sky130_fd_sc_hd__dlygate4sd3_1
XFILLER_45_169 VPWR VGND VPWR VGND sky130_ef_sc_hd__decap_12
XFILLER_45_103 VGND VGND VPWR VPWR sky130_fd_sc_hd__decap_8
XTAP_TAPCELL_ROW_43_348 VGND VPWR sky130_fd_sc_hd__tapvpwrvgnd_1
XTAP_TAPCELL_ROW_51_392 VGND VPWR sky130_fd_sc_hd__tapvpwrvgnd_1
XFILLER_5_265 VPWR VGND VPWR VGND sky130_ef_sc_hd__decap_12
XFILLER_5_221 VGND VGND VPWR VPWR sky130_fd_sc_hd__decap_3
XFILLER_30_81 VGND VGND VPWR VPWR sky130_fd_sc_hd__decap_3
Xinput8 a_in[7] VGND VGND VPWR VPWR net8 sky130_fd_sc_hd__clkbuf_1
X_1260_ _0574_ _0575_ _0585_ VGND VGND VPWR VPWR _0587_ sky130_fd_sc_hd__nand3_1
XFILLER_39_90 VPWR VGND VPWR VGND sky130_ef_sc_hd__decap_12
X_1191_ _0480_ _0485_ _0483_ VGND VGND VPWR VPWR _0519_ sky130_fd_sc_hd__o21ai_1
XFILLER_51_117 VGND VGND VPWR VPWR sky130_fd_sc_hd__fill_1
XFILLER_24_309 VGND VGND VPWR VPWR sky130_fd_sc_hd__fill_2
X_0975_ _0266_ _0296_ _0304_ _0305_ VGND VGND VPWR VPWR _0307_ sky130_fd_sc_hd__a22oi_4
XFILLER_10_29 VPWR VGND VPWR VGND sky130_ef_sc_hd__decap_12
X_1389_ clknet_3_7__leaf_clk _0015_ VGND VGND VPWR VPWR net42 sky130_fd_sc_hd__dfxtp_1
XFILLER_50_194 VGND VGND VPWR VPWR sky130_fd_sc_hd__fill_2
XFILLER_42_139 VGND VGND VPWR VPWR sky130_fd_sc_hd__fill_1
XFILLER_51_69 VGND VGND VPWR VPWR sky130_fd_sc_hd__decap_8
XFILLER_33_106 VGND VGND VPWR VPWR sky130_fd_sc_hd__decap_6
X_0760_ product_reg\[7\] net66 VGND VGND VPWR VPWR _0131_ sky130_fd_sc_hd__nor2_1
X_0691_ net66 VGND VGND VPWR VPWR _0071_ sky130_fd_sc_hd__inv_2
XFILLER_49_261 VGND VGND VPWR VPWR sky130_fd_sc_hd__fill_1
X_1312_ _0077_ net87 _0611_ _0079_ _0634_ VGND VGND VPWR VPWR _0637_ sky130_fd_sc_hd__o221ai_4
X_1243_ _0520_ _0553_ _0552_ VGND VGND VPWR VPWR _0570_ sky130_fd_sc_hd__o21ai_1
XFILLER_2_85 VGND VGND VPWR VPWR sky130_fd_sc_hd__decap_6
XFILLER_2_41 VPWR VGND VPWR VGND sky130_ef_sc_hd__decap_12
X_1174_ net132 net112 _0386_ _0384_ VGND VGND VPWR VPWR _0503_ sky130_fd_sc_hd__a31o_1
XFILLER_24_139 VGND VGND VPWR VPWR sky130_fd_sc_hd__fill_1
X_0889_ net364 net81 VGND VGND VPWR VPWR _0037_ sky130_fd_sc_hd__and2_1
X_0958_ net108 net109 net123 net119 VGND VGND VPWR VPWR _0290_ sky130_fd_sc_hd__nand4_2
XPHY_EDGE_ROW_6_Left_59 VGND VGND VPWR VPWR sky130_fd_sc_hd__decap_3
Xclone148 _0197_ VGND VGND VPWR VPWR net280 sky130_fd_sc_hd__buf_4
XFILLER_46_253 VGND VGND VPWR VPWR sky130_fd_sc_hd__decap_8
XFILLER_36_80 VGND VGND VPWR VPWR sky130_fd_sc_hd__decap_4
Xinput11 b_in[2] VGND VGND VPWR VPWR net11 sky130_fd_sc_hd__buf_1
X_0812_ _0170_ _0164_ _0173_ _0175_ VGND VGND VPWR VPWR _0177_ sky130_fd_sc_hd__and4_1
X_0743_ net76 net376 net82 _0116_ VGND VGND VPWR VPWR _0005_ sky130_fd_sc_hd__o211a_1
XFILLER_14_183 VPWR VGND VPWR VGND sky130_ef_sc_hd__decap_12
X_1226_ net230 _0522_ _0547_ _0548_ _0520_ VGND VGND VPWR VPWR _0554_ sky130_fd_sc_hd__a41oi_2
X_1157_ net111 net112 _0483_ _0484_ VGND VGND VPWR VPWR _0486_ sky130_fd_sc_hd__a22oi_4
XFILLER_52_245 VGND VGND VPWR VPWR sky130_fd_sc_hd__decap_6
XFILLER_32_27 VGND VGND VPWR VPWR sky130_fd_sc_hd__fill_1
X_1088_ _0410_ _0412_ net107 net116 VGND VGND VPWR VPWR _0418_ sky130_fd_sc_hd__and4_1
XFILLER_20_197 VPWR VGND VPWR VGND sky130_ef_sc_hd__decap_12
XFILLER_43_267 VPWR VGND VPWR VGND sky130_ef_sc_hd__decap_12
XFILLER_28_253 VGND VGND VPWR VPWR sky130_fd_sc_hd__decap_4
XFILLER_7_135 VGND VGND VPWR VPWR sky130_fd_sc_hd__decap_4
XFILLER_19_220 VGND VGND VPWR VPWR sky130_fd_sc_hd__decap_4
XFILLER_19_275 VGND VGND VPWR VPWR sky130_fd_sc_hd__decap_4
X_1011_ net104 net125 net119 net107 VGND VGND VPWR VPWR _0342_ sky130_fd_sc_hd__a22o_2
X_0726_ _0100_ _0101_ net76 VGND VGND VPWR VPWR _0102_ sky130_fd_sc_hd__o21ai_1
XFILLER_8_73 VGND VGND VPWR VPWR sky130_fd_sc_hd__decap_3
XTAP_TAPCELL_ROW_12_181 VGND VPWR sky130_fd_sc_hd__tapvpwrvgnd_1
XTAP_TAPCELL_ROW_4_138 VGND VPWR sky130_fd_sc_hd__tapvpwrvgnd_1
X_1209_ _0534_ _0535_ _0536_ net206 VGND VGND VPWR VPWR _0537_ sky130_fd_sc_hd__a22oi_4
XFILLER_16_212 VPWR VGND VPWR VGND sky130_ef_sc_hd__decap_12
XPHY_EDGE_ROW_9_Left_62 VGND VGND VPWR VPWR sky130_fd_sc_hd__decap_3
XFILLER_17_93 VGND VGND VPWR VPWR sky130_fd_sc_hd__fill_1
XFILLER_3_160 VGND VGND VPWR VPWR sky130_fd_sc_hd__decap_3
XFILLER_12_3 VPWR VGND VPWR VGND sky130_ef_sc_hd__decap_12
XTAP_TAPCELL_ROW_1_119 VGND VPWR sky130_fd_sc_hd__tapvpwrvgnd_1
XTAP_TAPCELL_ROW_32_287 VGND VPWR sky130_fd_sc_hd__tapvpwrvgnd_1
XFILLER_30_270 VGND VGND VPWR VPWR sky130_fd_sc_hd__decap_8
XFILLER_22_237 VGND VGND VPWR VPWR sky130_fd_sc_hd__fill_1
X_0709_ product_reg\[0\] net75 net360 VGND VGND VPWR VPWR _0087_ sky130_fd_sc_hd__a21oi_1
XPHY_EDGE_ROW_35_Left_88 VGND VGND VPWR VPWR sky130_fd_sc_hd__decap_3
XFILLER_13_237 VGND VGND VPWR VPWR sky130_fd_sc_hd__decap_3
XFILLER_0_141 VGND VGND VPWR VPWR sky130_fd_sc_hd__fill_2
XTAP_TAPCELL_ROW_46_368 VGND VPWR sky130_fd_sc_hd__tapvpwrvgnd_1
XFILLER_44_80 VGND VGND VPWR VPWR sky130_fd_sc_hd__decap_4
X_0991_ _0320_ _0322_ product_reg\[5\] _0232_ VGND VGND VPWR VPWR _0048_ sky130_fd_sc_hd__a2bb2o_4
XFILLER_39_189 VGND VGND VPWR VPWR sky130_fd_sc_hd__fill_2
XFILLER_39_167 VGND VGND VPWR VPWR sky130_fd_sc_hd__fill_1
XFILLER_10_218 VPWR VGND VPWR VGND sky130_ef_sc_hd__decap_12
XTAP_TAPCELL_ROW_20_224 VGND VPWR sky130_fd_sc_hd__tapvpwrvgnd_1
Xhold263 net93 VGND VGND VPWR VPWR net395 sky130_fd_sc_hd__dlygate4sd3_1
Xhold230 net5 VGND VGND VPWR VPWR net362 sky130_fd_sc_hd__dlygate4sd3_1
Xhold252 net56 VGND VGND VPWR VPWR net384 sky130_fd_sc_hd__dlygate4sd3_1
Xhold241 net40 VGND VGND VPWR VPWR net373 sky130_fd_sc_hd__dlygate4sd3_1
XTAP_TAPCELL_ROW_51_393 VGND VPWR sky130_fd_sc_hd__tapvpwrvgnd_1
XTAP_TAPCELL_ROW_43_349 VGND VPWR sky130_fd_sc_hd__tapvpwrvgnd_1
XFILLER_30_93 VGND VGND VPWR VPWR sky130_fd_sc_hd__decap_3
XFILLER_5_277 VGND VGND VPWR VPWR sky130_fd_sc_hd__decap_3
Xinput9 b_in[0] VGND VGND VPWR VPWR net9 sky130_fd_sc_hd__clkbuf_1
X_1190_ _0480_ _0483_ VGND VGND VPWR VPWR _0518_ sky130_fd_sc_hd__and2_1
X_0974_ _0304_ _0305_ VGND VGND VPWR VPWR _0306_ sky130_fd_sc_hd__nand2_1
X_1388_ clknet_3_7__leaf_clk _0014_ VGND VGND VPWR VPWR net41 sky130_fd_sc_hd__dfxtp_1
XFILLER_51_15 VPWR VGND VPWR VGND sky130_ef_sc_hd__decap_12
XFILLER_50_184 VGND VGND VPWR VPWR sky130_fd_sc_hd__decap_3
XFILLER_35_181 VPWR VGND VPWR VGND sky130_ef_sc_hd__decap_12
XFILLER_23_310 VGND VGND VPWR VPWR sky130_fd_sc_hd__fill_1
XFILLER_41_173 VGND VGND VPWR VPWR sky130_fd_sc_hd__fill_1
XPHY_EDGE_ROW_38_Left_91 VGND VGND VPWR VPWR sky130_fd_sc_hd__decap_3
X_0690_ net75 VGND VGND VPWR VPWR _0070_ sky130_fd_sc_hd__inv_2
X_1311_ _0635_ net113 net99 VGND VGND VPWR VPWR _0636_ sky130_fd_sc_hd__nand3_1
XPHY_EDGE_ROW_22_Left_75 VGND VGND VPWR VPWR sky130_fd_sc_hd__decap_3
XFILLER_2_53 VPWR VGND VPWR VGND sky130_ef_sc_hd__decap_12
XPHY_EDGE_ROW_10_Right_10 VGND VGND VPWR VPWR sky130_fd_sc_hd__decap_3
X_1173_ _0386_ net112 net132 VGND VGND VPWR VPWR _0502_ sky130_fd_sc_hd__and3_1
X_1242_ _0561_ net237 _0558_ VGND VGND VPWR VPWR _0569_ sky130_fd_sc_hd__a21o_1
X_0888_ net333 net81 VGND VGND VPWR VPWR _0036_ sky130_fd_sc_hd__and2_1
X_0957_ net109 net108 net123 net119 VGND VGND VPWR VPWR _0289_ sky130_fd_sc_hd__and4_1
XFILLER_14_195 VGND VGND VPWR VPWR sky130_fd_sc_hd__fill_1
Xinput12 b_in[3] VGND VGND VPWR VPWR net12 sky130_fd_sc_hd__clkbuf_1
X_0811_ _0164_ _0170_ _0173_ _0175_ VGND VGND VPWR VPWR _0176_ sky130_fd_sc_hd__a22o_1
X_0742_ _0114_ _0115_ _0070_ VGND VGND VPWR VPWR _0116_ sky130_fd_sc_hd__a21o_1
X_1225_ _0492_ net135 _0549_ _0550_ VGND VGND VPWR VPWR _0553_ sky130_fd_sc_hd__a22oi_4
X_1087_ net107 net116 _0409_ _0411_ VGND VGND VPWR VPWR _0417_ sky130_fd_sc_hd__o2bb2a_2
X_1156_ _0484_ VGND VGND VPWR VPWR _0485_ sky130_fd_sc_hd__inv_2
XFILLER_20_176 VGND VGND VPWR VPWR sky130_fd_sc_hd__fill_1
XFILLER_4_309 VGND VGND VPWR VPWR sky130_fd_sc_hd__fill_2
XFILLER_43_279 VGND VGND VPWR VPWR sky130_fd_sc_hd__fill_1
XFILLER_43_213 VGND VGND VPWR VPWR sky130_fd_sc_hd__decap_8
XFILLER_7_169 VGND VGND VPWR VPWR sky130_fd_sc_hd__fill_1
XFILLER_22_61 VGND VGND VPWR VPWR sky130_fd_sc_hd__decap_4
XFILLER_22_83 VGND VGND VPWR VPWR sky130_fd_sc_hd__fill_1
X_1010_ net104 net123 net119 net107 VGND VGND VPWR VPWR _0341_ sky130_fd_sc_hd__a22oi_4
XTAP_TAPCELL_ROW_29_271 VGND VPWR sky130_fd_sc_hd__tapvpwrvgnd_1
XFILLER_8_41 VGND VGND VPWR VPWR sky130_fd_sc_hd__fill_1
X_0725_ _0090_ _0095_ _0097_ _0099_ VGND VGND VPWR VPWR _0101_ sky130_fd_sc_hd__and4_1
XTAP_TAPCELL_ROW_12_182 VGND VPWR sky130_fd_sc_hd__tapvpwrvgnd_1
X_1208_ _0455_ _0458_ _0470_ VGND VGND VPWR VPWR _0536_ sky130_fd_sc_hd__o21ai_4
XFILLER_27_17 VGND VGND VPWR VPWR sky130_fd_sc_hd__decap_3
XFILLER_40_249 VGND VGND VPWR VPWR sky130_fd_sc_hd__decap_3
X_1139_ _0395_ net174 _0459_ _0462_ _0399_ VGND VGND VPWR VPWR _0468_ sky130_fd_sc_hd__o221ai_4
XFILLER_4_139 VGND VGND VPWR VPWR sky130_fd_sc_hd__fill_1
XFILLER_16_224 VPWR VGND VPWR VGND sky130_ef_sc_hd__decap_12
XFILLER_16_268 VPWR VGND VPWR VGND sky130_ef_sc_hd__decap_12
XFILLER_3_172 VGND VGND VPWR VPWR sky130_fd_sc_hd__fill_1
XPHY_EDGE_ROW_8_Right_8 VGND VGND VPWR VPWR sky130_fd_sc_hd__decap_3
XTAP_TAPCELL_ROW_32_288 VGND VPWR sky130_fd_sc_hd__tapvpwrvgnd_1
XPHY_EDGE_ROW_39_Right_39 VGND VGND VPWR VPWR sky130_fd_sc_hd__decap_3
XFILLER_38_27 VGND VGND VPWR VPWR sky130_fd_sc_hd__fill_1
X_0708_ _0086_ VGND VGND VPWR VPWR _0000_ sky130_fd_sc_hd__inv_2
XPHY_EDGE_ROW_48_Right_48 VGND VGND VPWR VPWR sky130_fd_sc_hd__decap_3
XFILLER_0_175 VGND VGND VPWR VPWR sky130_fd_sc_hd__decap_3
XFILLER_0_197 VPWR VGND VPWR VGND sky130_ef_sc_hd__decap_12
XTAP_TAPCELL_ROW_46_369 VGND VPWR sky130_fd_sc_hd__tapvpwrvgnd_1
XFILLER_8_253 VPWR VGND VPWR VGND sky130_ef_sc_hd__decap_12
X_0990_ _0281_ _0319_ _0284_ _0086_ VGND VGND VPWR VPWR _0322_ sky130_fd_sc_hd__a31o_1
XFILLER_39_113 VPWR VGND VPWR VGND sky130_ef_sc_hd__decap_12
XFILLER_39_102 VGND VGND VPWR VPWR sky130_fd_sc_hd__decap_8
Xhold253 net60 VGND VGND VPWR VPWR net385 sky130_fd_sc_hd__dlygate4sd3_1
Xhold242 net67 VGND VGND VPWR VPWR net374 sky130_fd_sc_hd__dlygate4sd3_1
XTAP_TAPCELL_ROW_20_225 VGND VPWR sky130_fd_sc_hd__tapvpwrvgnd_1
Xhold264 product_reg\[14\] VGND VGND VPWR VPWR net396 sky130_fd_sc_hd__dlygate4sd3_1
XTAP_TAPCELL_ROW_51_394 VGND VPWR sky130_fd_sc_hd__tapvpwrvgnd_1
X_0973_ _0301_ _0303_ net103 net126 VGND VGND VPWR VPWR _0305_ sky130_fd_sc_hd__nand4_4
X_1387_ clknet_3_6__leaf_clk _0013_ VGND VGND VPWR VPWR net40 sky130_fd_sc_hd__dfxtp_1
XFILLER_27_127 VPWR VGND VPWR VGND sky130_ef_sc_hd__decap_12
XFILLER_51_27 VPWR VGND VPWR VGND sky130_ef_sc_hd__decap_12
XFILLER_35_193 VPWR VGND VPWR VGND sky130_ef_sc_hd__decap_12
XFILLER_18_105 VGND VGND VPWR VPWR sky130_fd_sc_hd__fill_1
XFILLER_18_116 VPWR VGND VPWR VGND sky130_ef_sc_hd__decap_12
Xrebuffer90 net227 VGND VGND VPWR VPWR net222 sky130_fd_sc_hd__dlymetal6s2s_1
XFILLER_25_50 VGND VGND VPWR VPWR sky130_fd_sc_hd__decap_6
XFILLER_25_94 VGND VGND VPWR VPWR sky130_fd_sc_hd__fill_1
XFILLER_41_185 VGND VGND VPWR VPWR sky130_fd_sc_hd__fill_2
Xrebuffer180 net310 VGND VGND VPWR VPWR net312 sky130_fd_sc_hd__dlymetal6s4s_1
X_1310_ _0079_ _0611_ _0634_ VGND VGND VPWR VPWR _0635_ sky130_fd_sc_hd__o21ai_1
XFILLER_1_281 VPWR VGND VPWR VGND sky130_ef_sc_hd__decap_12
X_1241_ _0504_ _0510_ _0561_ VGND VGND VPWR VPWR _0568_ sky130_fd_sc_hd__o21ai_2
XFILLER_2_65 VPWR VGND VPWR VGND sky130_ef_sc_hd__decap_12
X_1172_ _0075_ net87 _0385_ VGND VGND VPWR VPWR _0501_ sky130_fd_sc_hd__o21a_1
XFILLER_32_163 VGND VGND VPWR VPWR sky130_fd_sc_hd__fill_1
X_0956_ _0263_ _0268_ _0269_ _0273_ _0278_ VGND VGND VPWR VPWR _0288_ sky130_fd_sc_hd__a32o_1
X_0887_ net350 net80 VGND VGND VPWR VPWR _0035_ sky130_fd_sc_hd__nor2_1
X_1439_ clknet_3_5__leaf_clk _0065_ VGND VGND VPWR VPWR net35 sky130_fd_sc_hd__dfxtp_1
XFILLER_7_307 VGND VGND VPWR VPWR sky130_fd_sc_hd__decap_4
XFILLER_23_185 VPWR VGND VPWR VGND sky130_ef_sc_hd__decap_12
XFILLER_2_3 VPWR VGND VPWR VGND sky130_ef_sc_hd__decap_12
XFILLER_46_222 VPWR VGND VPWR VGND sky130_ef_sc_hd__decap_12
XFILLER_52_81 VGND VGND VPWR VPWR sky130_fd_sc_hd__decap_3
X_0810_ product_reg\[13\] net41 VGND VGND VPWR VPWR _0175_ sky130_fd_sc_hd__nand2_1
Xinput13 b_in[4] VGND VGND VPWR VPWR net13 sky130_fd_sc_hd__clkbuf_1
X_0741_ _0113_ net182 VGND VGND VPWR VPWR _0115_ sky130_fd_sc_hd__or2_1
XFILLER_37_233 VGND VGND VPWR VPWR sky130_fd_sc_hd__fill_2
XFILLER_35_3 VGND VGND VPWR VPWR sky130_fd_sc_hd__decap_3
X_1224_ _0478_ _0521_ _0547_ _0548_ VGND VGND VPWR VPWR _0552_ sky130_fd_sc_hd__a2bb2o_2
X_1155_ _0408_ _0409_ _0412_ _0481_ VGND VGND VPWR VPWR _0484_ sky130_fd_sc_hd__o211ai_4
X_1086_ _0409_ _0411_ _0408_ VGND VGND VPWR VPWR _0416_ sky130_fd_sc_hd__o21bai_1
XFILLER_32_29 VGND VGND VPWR VPWR sky130_fd_sc_hd__decap_3
X_0939_ _0263_ _0268_ _0269_ VGND VGND VPWR VPWR _0272_ sky130_fd_sc_hd__nand3_2
XFILLER_20_144 VGND VGND VPWR VPWR sky130_fd_sc_hd__decap_6
XFILLER_43_225 VGND VGND VPWR VPWR sky130_fd_sc_hd__decap_8
XFILLER_19_211 VGND VGND VPWR VPWR sky130_fd_sc_hd__fill_2
XFILLER_34_203 VGND VGND VPWR VPWR sky130_fd_sc_hd__fill_1
XFILLER_19_233 VGND VGND VPWR VPWR sky130_fd_sc_hd__decap_3
XTAP_TAPCELL_ROW_29_272 VGND VPWR sky130_fd_sc_hd__tapvpwrvgnd_1
X_0724_ _0095_ _0097_ _0098_ _0089_ VGND VGND VPWR VPWR _0100_ sky130_fd_sc_hd__o2bb2a_1
X_1207_ _0532_ _0533_ _0523_ VGND VGND VPWR VPWR _0535_ sky130_fd_sc_hd__nand3_4
X_1069_ net221 net313 net227 net91 VGND VGND VPWR VPWR _0399_ sky130_fd_sc_hd__nand4_4
X_1138_ _0463_ _0460_ _0465_ net207 VGND VGND VPWR VPWR _0467_ sky130_fd_sc_hd__a22oi_4
XFILLER_4_118 VPWR VGND VPWR VGND sky130_ef_sc_hd__decap_12
XFILLER_16_203 VGND VGND VPWR VPWR sky130_fd_sc_hd__fill_2
XFILLER_16_236 VGND VGND VPWR VPWR sky130_fd_sc_hd__decap_8
XFILLER_33_94 VPWR VGND VPWR VGND sky130_ef_sc_hd__decap_12
XFILLER_39_306 VGND VGND VPWR VPWR sky130_fd_sc_hd__fill_1
XTAP_TAPCELL_ROW_32_289 VGND VPWR sky130_fd_sc_hd__tapvpwrvgnd_1
X_0707_ net17 net18 _0085_ VGND VGND VPWR VPWR _0086_ sky130_fd_sc_hd__or3_2
XFILLER_38_39 VGND VGND VPWR VPWR sky130_fd_sc_hd__decap_6
XFILLER_38_17 VGND VGND VPWR VPWR sky130_fd_sc_hd__fill_1
XTAP_TAPCELL_ROW_0_110 VGND VPWR sky130_fd_sc_hd__tapvpwrvgnd_1
XFILLER_21_250 VPWR VGND VPWR VGND sky130_ef_sc_hd__decap_12
XFILLER_36_309 VGND VGND VPWR VPWR sky130_fd_sc_hd__fill_2
XFILLER_8_265 VGND VGND VPWR VPWR sky130_fd_sc_hd__decap_4
XFILLER_12_250 VGND VGND VPWR VPWR sky130_fd_sc_hd__fill_2
XFILLER_39_125 VPWR VGND VPWR VGND sky130_ef_sc_hd__decap_12
XFILLER_39_169 VPWR VGND VPWR VGND sky130_ef_sc_hd__decap_12
XTAP_TAPCELL_ROW_37_315 VGND VPWR sky130_fd_sc_hd__tapvpwrvgnd_1
XTAP_TAPCELL_ROW_20_226 VGND VPWR sky130_fd_sc_hd__tapvpwrvgnd_1
Xhold254 _0081_ VGND VGND VPWR VPWR net386 sky130_fd_sc_hd__dlygate4sd3_1
Xhold221 _0076_ VGND VGND VPWR VPWR net353 sky130_fd_sc_hd__dlygate4sd3_1
Xhold265 _0632_ VGND VGND VPWR VPWR net397 sky130_fd_sc_hd__dlygate4sd3_1
Xhold232 net106 VGND VGND VPWR VPWR net364 sky130_fd_sc_hd__dlygate4sd3_1
Xhold243 net62 VGND VGND VPWR VPWR net375 sky130_fd_sc_hd__dlygate4sd3_1
XFILLER_18_309 VGND VGND VPWR VPWR sky130_fd_sc_hd__fill_2
XFILLER_45_128 VPWR VGND VPWR VGND sky130_ef_sc_hd__decap_12
XTAP_TAPCELL_ROW_51_395 VGND VPWR sky130_fd_sc_hd__tapvpwrvgnd_1
XFILLER_14_85 VGND VGND VPWR VPWR sky130_fd_sc_hd__decap_4
XFILLER_44_194 VGND VGND VPWR VPWR sky130_fd_sc_hd__fill_2
X_0972_ _0073_ _0074_ _0300_ _0302_ VGND VGND VPWR VPWR _0304_ sky130_fd_sc_hd__o22ai_4
X_1386_ clknet_3_6__leaf_clk _0012_ VGND VGND VPWR VPWR net39 sky130_fd_sc_hd__dfxtp_1
XFILLER_19_19 VGND VGND VPWR VPWR sky130_fd_sc_hd__decap_3
XFILLER_50_120 VGND VGND VPWR VPWR sky130_fd_sc_hd__fill_1
XFILLER_27_139 VPWR VGND VPWR VGND sky130_ef_sc_hd__decap_12
XFILLER_51_39 VPWR VGND VPWR VGND sky130_ef_sc_hd__decap_12
XFILLER_18_128 VPWR VGND VPWR VGND sky130_ef_sc_hd__decap_12
Xrebuffer91 net96 VGND VGND VPWR VPWR net223 sky130_fd_sc_hd__buf_2
Xrebuffer80 _0405_ VGND VGND VPWR VPWR net212 sky130_fd_sc_hd__buf_1
Xrebuffer181 net130 VGND VGND VPWR VPWR net313 sky130_fd_sc_hd__dlygate4sd1_1
XFILLER_2_77 VGND VGND VPWR VPWR sky130_fd_sc_hd__decap_6
XFILLER_1_293 VGND VGND VPWR VPWR sky130_fd_sc_hd__decap_4
X_1171_ _0392_ net140 net177 _0495_ _0496_ VGND VGND VPWR VPWR _0500_ sky130_fd_sc_hd__o2111ai_4
X_1240_ _0562_ net235 _0514_ net238 VGND VGND VPWR VPWR _0567_ sky130_fd_sc_hd__nand4_4
X_0886_ net321 net84 VGND VGND VPWR VPWR _0033_ sky130_fd_sc_hd__and2_1
X_0955_ _0263_ _0268_ _0269_ _0273_ _0278_ VGND VGND VPWR VPWR _0287_ sky130_fd_sc_hd__a32oi_4
X_1438_ clknet_3_5__leaf_clk _0064_ VGND VGND VPWR VPWR net34 sky130_fd_sc_hd__dfxtp_1
X_1369_ net358 net81 VGND VGND VPWR VPWR _0062_ sky130_fd_sc_hd__and2_1
XFILLER_23_197 VGND VGND VPWR VPWR sky130_fd_sc_hd__decap_6
XFILLER_46_245 VGND VGND VPWR VPWR sky130_fd_sc_hd__decap_6
XFILLER_46_234 VGND VGND VPWR VPWR sky130_fd_sc_hd__decap_3
Xinput14 b_in[5] VGND VGND VPWR VPWR net14 sky130_fd_sc_hd__clkbuf_1
X_0740_ _0106_ net159 _0111_ _0112_ _0104_ VGND VGND VPWR VPWR _0114_ sky130_fd_sc_hd__a221o_1
X_1223_ _0478_ _0521_ _0547_ _0548_ VGND VGND VPWR VPWR _0551_ sky130_fd_sc_hd__a2bb2oi_2
XFILLER_28_3 VGND VGND VPWR VPWR sky130_fd_sc_hd__decap_6
X_1154_ _0482_ net114 net107 _0410_ VGND VGND VPWR VPWR _0483_ sky130_fd_sc_hd__nand4_4
X_1085_ _0409_ _0411_ net107 net116 VGND VGND VPWR VPWR _0415_ sky130_fd_sc_hd__o211a_1
X_0869_ net55 net72 _0210_ _0216_ net384 VGND VGND VPWR VPWR _0220_ sky130_fd_sc_hd__a41oi_1
X_0938_ net103 net88 net225 net102 _0264_ VGND VGND VPWR VPWR _0271_ sky130_fd_sc_hd__a41o_1
XFILLER_28_278 VPWR VGND VPWR VGND sky130_ef_sc_hd__decap_12
XFILLER_51_281 VGND VGND VPWR VPWR sky130_fd_sc_hd__decap_4
XFILLER_7_116 VGND VGND VPWR VPWR sky130_fd_sc_hd__fill_2
XFILLER_22_85 VPWR VGND VPWR VGND sky130_ef_sc_hd__decap_12
XTAP_TAPCELL_ROW_29_273 VGND VPWR sky130_fd_sc_hd__tapvpwrvgnd_1
X_0723_ product_reg\[1\] net276 net37 product_reg\[0\] VGND VGND VPWR VPWR _0099_
+ sky130_fd_sc_hd__a22o_1
XFILLER_6_182 VPWR VGND VPWR VGND sky130_ef_sc_hd__decap_12
X_1206_ _0523_ _0530_ _0531_ VGND VGND VPWR VPWR _0534_ sky130_fd_sc_hd__nand3b_4
X_1137_ _0397_ net98 net127 net156 VGND VGND VPWR VPWR _0466_ sky130_fd_sc_hd__a31o_1
X_1068_ net90 net94 net130 net91 VGND VGND VPWR VPWR _0398_ sky130_fd_sc_hd__and4_4
XTAP_TAPCELL_ROW_3_130 VGND VPWR sky130_fd_sc_hd__tapvpwrvgnd_1
XFILLER_17_85 VGND VGND VPWR VPWR sky130_fd_sc_hd__decap_8
XFILLER_24_270 VPWR VGND VPWR VGND sky130_ef_sc_hd__decap_12
XTAP_TAPCELL_ROW_26_254 VGND VPWR sky130_fd_sc_hd__tapvpwrvgnd_1
XFILLER_15_281 VGND VGND VPWR VPWR sky130_fd_sc_hd__decap_3
X_0706_ net319 net85 VGND VGND VPWR VPWR _0034_ sky130_fd_sc_hd__and2_1
XTAP_TAPCELL_ROW_0_111 VGND VPWR sky130_fd_sc_hd__tapvpwrvgnd_1
XFILLER_21_262 VPWR VGND VPWR VGND sky130_ef_sc_hd__decap_12
XFILLER_0_133 VGND VGND VPWR VPWR sky130_fd_sc_hd__decap_3
XFILLER_0_155 VGND VGND VPWR VPWR sky130_fd_sc_hd__fill_2
XFILLER_39_137 VPWR VGND VPWR VGND sky130_ef_sc_hd__decap_12
XFILLER_10_3 VPWR VGND VPWR VGND sky130_ef_sc_hd__decap_12
XTAP_TAPCELL_ROW_45_360 VGND VPWR sky130_fd_sc_hd__tapvpwrvgnd_1
XTAP_TAPCELL_ROW_37_316 VGND VPWR sky130_fd_sc_hd__tapvpwrvgnd_1
Xhold222 _0079_ VGND VGND VPWR VPWR net354 sky130_fd_sc_hd__dlygate4sd3_1
Xhold255 net115 VGND VGND VPWR VPWR net387 sky130_fd_sc_hd__dlygate4sd3_1
Xhold244 net63 VGND VGND VPWR VPWR net376 sky130_fd_sc_hd__dlygate4sd3_1
Xhold211 _0362_ VGND VGND VPWR VPWR net343 sky130_fd_sc_hd__dlygate4sd3_1
XTAP_TAPCELL_ROW_51_396 VGND VPWR sky130_fd_sc_hd__tapvpwrvgnd_1
XFILLER_5_225 VPWR VGND VPWR VGND sky130_ef_sc_hd__decap_12
XFILLER_14_64 VGND VGND VPWR VPWR sky130_fd_sc_hd__decap_4
XFILLER_14_97 VGND VGND VPWR VPWR sky130_fd_sc_hd__decap_3
XFILLER_30_85 VGND VGND VPWR VPWR sky130_fd_sc_hd__decap_8
XFILLER_29_181 VPWR VGND VPWR VGND sky130_ef_sc_hd__decap_12
X_0971_ net88 net128 net102 net100 VGND VGND VPWR VPWR _0303_ sky130_fd_sc_hd__nand4_2
X_1385_ clknet_3_6__leaf_clk _0011_ VGND VGND VPWR VPWR net38 sky130_fd_sc_hd__dfxtp_1
XFILLER_14_302 VGND VGND VPWR VPWR sky130_fd_sc_hd__fill_1
Xrebuffer81 _0563_ VGND VGND VPWR VPWR net213 sky130_fd_sc_hd__clkbuf_2
XFILLER_41_198 VGND VGND VPWR VPWR sky130_fd_sc_hd__fill_2
Xrebuffer92 net223 VGND VGND VPWR VPWR net224 sky130_fd_sc_hd__buf_2
X_1170_ _0392_ net138 _0430_ _0496_ VGND VGND VPWR VPWR _0499_ sky130_fd_sc_hd__o211ai_4
XFILLER_20_305 VGND VGND VPWR VPWR sky130_fd_sc_hd__decap_3
X_0885_ net370 _0230_ net85 _0231_ VGND VGND VPWR VPWR _0032_ sky130_fd_sc_hd__o211a_1
X_0954_ net78 _0285_ _0286_ VGND VGND VPWR VPWR _0047_ sky130_fd_sc_hd__a21oi_1
X_1437_ clknet_3_0__leaf_clk _0063_ VGND VGND VPWR VPWR net33 sky130_fd_sc_hd__dfxtp_1
X_1299_ _0623_ _0622_ _0621_ VGND VGND VPWR VPWR _0625_ sky130_fd_sc_hd__nand3_1
X_1368_ net347 net80 VGND VGND VPWR VPWR _0061_ sky130_fd_sc_hd__nor2_1
XFILLER_11_43 VGND VGND VPWR VPWR sky130_fd_sc_hd__decap_4
XFILLER_11_98 VGND VGND VPWR VPWR sky130_fd_sc_hd__fill_2
Xinput15 b_in[6] VGND VGND VPWR VPWR net15 sky130_fd_sc_hd__buf_1
XPHY_EDGE_ROW_26_Left_79 VGND VGND VPWR VPWR sky130_fd_sc_hd__decap_3
XFILLER_42_6 VGND VGND VPWR VPWR sky130_fd_sc_hd__fill_2
X_1222_ _0537_ _0539_ _0544_ _0545_ VGND VGND VPWR VPWR _0550_ sky130_fd_sc_hd__nand4b_2
X_1153_ _0408_ _0412_ VGND VGND VPWR VPWR _0482_ sky130_fd_sc_hd__nand2_1
X_1084_ _0408_ _0410_ _0412_ VGND VGND VPWR VPWR _0414_ sky130_fd_sc_hd__nand3_1
X_0868_ net55 _0218_ _0219_ net85 VGND VGND VPWR VPWR _0027_ sky130_fd_sc_hd__o211a_1
X_0799_ _0163_ _0164_ VGND VGND VPWR VPWR _0165_ sky130_fd_sc_hd__and2_1
X_0937_ net106 net126 _0266_ _0267_ VGND VGND VPWR VPWR _0270_ sky130_fd_sc_hd__a22o_1
XFILLER_28_224 VPWR VGND VPWR VGND sky130_ef_sc_hd__decap_12
XFILLER_28_257 VGND VGND VPWR VPWR sky130_fd_sc_hd__fill_1
XFILLER_22_97 VGND VGND VPWR VPWR sky130_fd_sc_hd__decap_6
XFILLER_19_279 VGND VGND VPWR VPWR sky130_fd_sc_hd__fill_1
Xclkbuf_3_4__f_clk clknet_0_clk VGND VGND VPWR VPWR clknet_3_4__leaf_clk sky130_fd_sc_hd__clkbuf_16
XTAP_TAPCELL_ROW_29_274 VGND VPWR sky130_fd_sc_hd__tapvpwrvgnd_1
XFILLER_6_194 VGND VGND VPWR VPWR sky130_fd_sc_hd__fill_2
X_0722_ net48 product_reg\[1\] net37 product_reg\[0\] VGND VGND VPWR VPWR _0098_ sky130_fd_sc_hd__a22oi_4
XFILLER_8_99 VGND VGND VPWR VPWR sky130_fd_sc_hd__fill_1
XFILLER_40_3 VGND VGND VPWR VPWR sky130_fd_sc_hd__fill_1
X_1205_ _0526_ _0529_ net101 net117 VGND VGND VPWR VPWR _0533_ sky130_fd_sc_hd__nand4_1
X_1136_ _0395_ _0399_ VGND VGND VPWR VPWR _0465_ sky130_fd_sc_hd__nand2_4
X_1067_ net94 net209 net91 net221 VGND VGND VPWR VPWR _0397_ sky130_fd_sc_hd__a22o_4
XFILLER_33_271 VGND VGND VPWR VPWR sky130_fd_sc_hd__fill_2
XTAP_TAPCELL_ROW_3_131 VGND VPWR sky130_fd_sc_hd__tapvpwrvgnd_1
XTAP_TAPCELL_ROW_26_255 VGND VPWR sky130_fd_sc_hd__tapvpwrvgnd_1
X_0705_ net20 net19 VGND VGND VPWR VPWR _0085_ sky130_fd_sc_hd__nand2_2
XPHY_EDGE_ROW_29_Left_82 VGND VGND VPWR VPWR sky130_fd_sc_hd__decap_3
XPHY_EDGE_ROW_13_Left_66 VGND VGND VPWR VPWR sky130_fd_sc_hd__decap_3
XTAP_TAPCELL_ROW_48_380 VGND VPWR sky130_fd_sc_hd__tapvpwrvgnd_1
XTAP_TAPCELL_ROW_0_112 VGND VPWR sky130_fd_sc_hd__tapvpwrvgnd_1
X_1119_ _0321_ _0377_ _0445_ VGND VGND VPWR VPWR _0449_ sky130_fd_sc_hd__or3_1
XPHY_EDGE_ROW_17_Right_17 VGND VGND VPWR VPWR sky130_fd_sc_hd__decap_3
XFILLER_21_274 VGND VGND VPWR VPWR sky130_fd_sc_hd__fill_1
XPHY_EDGE_ROW_26_Right_26 VGND VGND VPWR VPWR sky130_fd_sc_hd__decap_3
XFILLER_0_189 VGND VGND VPWR VPWR sky130_fd_sc_hd__decap_6
XFILLER_28_85 VGND VGND VPWR VPWR sky130_fd_sc_hd__decap_8
XPHY_EDGE_ROW_35_Right_35 VGND VGND VPWR VPWR sky130_fd_sc_hd__decap_3
XFILLER_12_296 VGND VGND VPWR VPWR sky130_fd_sc_hd__fill_1
XPHY_EDGE_ROW_44_Right_44 VGND VGND VPWR VPWR sky130_fd_sc_hd__decap_3
XFILLER_39_149 VPWR VGND VPWR VGND sky130_ef_sc_hd__decap_12
XTAP_TAPCELL_ROW_45_361 VGND VPWR sky130_fd_sc_hd__tapvpwrvgnd_1
XTAP_TAPCELL_ROW_37_317 VGND VPWR sky130_fd_sc_hd__tapvpwrvgnd_1
Xhold201 net109 VGND VGND VPWR VPWR net333 sky130_fd_sc_hd__dlygate4sd3_1
Xhold234 net87 VGND VGND VPWR VPWR net366 sky130_fd_sc_hd__dlygate4sd3_1
XFILLER_49_18 VPWR VGND VPWR VGND sky130_ef_sc_hd__decap_12
Xhold212 product_reg\[10\] VGND VGND VPWR VPWR net344 sky130_fd_sc_hd__dlygate4sd3_1
Xhold256 net132 VGND VGND VPWR VPWR net388 sky130_fd_sc_hd__dlygate4sd3_1
Xhold245 net65 VGND VGND VPWR VPWR net377 sky130_fd_sc_hd__dlygate4sd3_1
XFILLER_5_237 VGND VGND VPWR VPWR sky130_fd_sc_hd__fill_2
XFILLER_29_193 VGND VGND VPWR VPWR sky130_fd_sc_hd__decap_6
XTAP_TAPCELL_ROW_42_342 VGND VPWR sky130_fd_sc_hd__tapvpwrvgnd_1
X_0970_ net88 net128 net102 net100 VGND VGND VPWR VPWR _0302_ sky130_fd_sc_hd__and4_4
X_1384_ clknet_3_3__leaf_clk _0010_ VGND VGND VPWR VPWR net68 sky130_fd_sc_hd__dfxtp_2
XFILLER_35_141 VPWR VGND VPWR VGND sky130_ef_sc_hd__decap_12
XFILLER_41_111 VGND VGND VPWR VPWR sky130_fd_sc_hd__fill_1
Xrebuffer93 net308 VGND VGND VPWR VPWR net225 sky130_fd_sc_hd__clkbuf_2
XFILLER_26_141 VGND VGND VPWR VPWR sky130_fd_sc_hd__decap_6
Xrebuffer82 _0406_ VGND VGND VPWR VPWR net214 sky130_fd_sc_hd__buf_6
XFILLER_32_188 VGND VGND VPWR VPWR sky130_fd_sc_hd__decap_8
X_0884_ _0227_ net385 net370 VGND VGND VPWR VPWR _0231_ sky130_fd_sc_hd__nand3_2
X_0953_ net359 net78 net82 VGND VGND VPWR VPWR _0286_ sky130_fd_sc_hd__o21ai_1
X_1367_ net211 net81 VGND VGND VPWR VPWR _0060_ sky130_fd_sc_hd__and2_1
X_1436_ clknet_3_0__leaf_clk _0062_ VGND VGND VPWR VPWR net32 sky130_fd_sc_hd__dfxtp_1
X_1298_ _0621_ _0622_ _0623_ VGND VGND VPWR VPWR _0624_ sky130_fd_sc_hd__a21oi_2
XFILLER_23_177 VGND VGND VPWR VPWR sky130_fd_sc_hd__fill_1
XFILLER_36_85 VGND VGND VPWR VPWR sky130_fd_sc_hd__decap_6
XPHY_EDGE_ROW_1_Left_54 VGND VGND VPWR VPWR sky130_fd_sc_hd__decap_3
Xinput16 b_in[7] VGND VGND VPWR VPWR net16 sky130_fd_sc_hd__buf_1
X_1221_ _0537_ _0538_ _0546_ VGND VGND VPWR VPWR _0549_ sky130_fd_sc_hd__o21ai_1
X_1083_ _0408_ _0410_ _0412_ VGND VGND VPWR VPWR _0413_ sky130_fd_sc_hd__and3_1
X_1152_ net107 net114 VGND VGND VPWR VPWR _0481_ sky130_fd_sc_hd__nand2_1
X_0936_ _0266_ _0267_ _0264_ VGND VGND VPWR VPWR _0269_ sky130_fd_sc_hd__a21o_1
XTAP_TAPCELL_ROW_15_194 VGND VPWR sky130_fd_sc_hd__tapvpwrvgnd_1
X_0867_ net394 net280 net74 _0216_ VGND VGND VPWR VPWR _0219_ sky130_fd_sc_hd__nand4_1
X_0798_ product_reg\[12\] net40 VGND VGND VPWR VPWR _0164_ sky130_fd_sc_hd__nand2_1
XPHY_EDGE_ROW_43_Left_96 VGND VGND VPWR VPWR sky130_fd_sc_hd__decap_3
X_1419_ clknet_3_2__leaf_clk _0045_ VGND VGND VPWR VPWR product_reg\[2\] sky130_fd_sc_hd__dfxtp_1
XFILLER_28_236 VGND VGND VPWR VPWR sky130_fd_sc_hd__fill_2
XFILLER_0_3 VPWR VGND VPWR VGND sky130_ef_sc_hd__decap_12
XFILLER_19_203 VGND VGND VPWR VPWR sky130_fd_sc_hd__decap_8
XFILLER_19_225 VGND VGND VPWR VPWR sky130_fd_sc_hd__decap_8
XTAP_TAPCELL_ROW_29_275 VGND VPWR sky130_fd_sc_hd__tapvpwrvgnd_1
X_0721_ product_reg\[2\] net59 VGND VGND VPWR VPWR _0097_ sky130_fd_sc_hd__or2_1
X_1204_ _0076_ _0078_ _0525_ _0528_ VGND VGND VPWR VPWR _0532_ sky130_fd_sc_hd__o22ai_2
XFILLER_33_3 VGND VGND VPWR VPWR sky130_fd_sc_hd__decap_8
X_1135_ _0074_ _0080_ _0329_ _0460_ VGND VGND VPWR VPWR _0464_ sky130_fd_sc_hd__o31a_1
X_1066_ net94 net130 net91 net218 VGND VGND VPWR VPWR _0396_ sky130_fd_sc_hd__a22oi_4
X_0919_ _0250_ _0251_ _0252_ VGND VGND VPWR VPWR _0253_ sky130_fd_sc_hd__a21oi_1
XFILLER_0_305 VGND VGND VPWR VPWR sky130_fd_sc_hd__decap_3
XFILLER_48_309 VGND VGND VPWR VPWR sky130_fd_sc_hd__fill_2
XTAP_TAPCELL_ROW_3_132 VGND VPWR sky130_fd_sc_hd__tapvpwrvgnd_1
XFILLER_17_65 VGND VGND VPWR VPWR sky130_fd_sc_hd__decap_3
XFILLER_33_42 VGND VGND VPWR VPWR sky130_fd_sc_hd__fill_1
XTAP_TAPCELL_ROW_26_256 VGND VPWR sky130_fd_sc_hd__tapvpwrvgnd_1
X_0704_ net20 net19 VGND VGND VPWR VPWR _0084_ sky130_fd_sc_hd__and2_1
XTAP_TAPCELL_ROW_0_113 VGND VPWR sky130_fd_sc_hd__tapvpwrvgnd_1
XFILLER_0_90 VPWR VGND VPWR VGND sky130_ef_sc_hd__decap_12
X_1049_ _0378_ _0379_ _0000_ _0232_ net322 VGND VGND VPWR VPWR _0049_ sky130_fd_sc_hd__a32o_1
X_1118_ _0442_ _0446_ _0445_ VGND VGND VPWR VPWR _0448_ sky130_fd_sc_hd__o21bai_1
XFILLER_21_297 VGND VGND VPWR VPWR sky130_fd_sc_hd__fill_2
XFILLER_0_102 VGND VGND VPWR VPWR sky130_fd_sc_hd__decap_6
XFILLER_0_113 VPWR VGND VPWR VGND sky130_ef_sc_hd__decap_12
XFILLER_44_52 VGND VGND VPWR VPWR sky130_fd_sc_hd__fill_1
XFILLER_12_253 VGND VGND VPWR VPWR sky130_fd_sc_hd__decap_4
XPHY_EDGE_ROW_30_Left_83 VGND VGND VPWR VPWR sky130_fd_sc_hd__decap_3
XFILLER_5_68 VGND VGND VPWR VPWR sky130_fd_sc_hd__decap_8
XTAP_TAPCELL_ROW_37_318 VGND VPWR sky130_fd_sc_hd__tapvpwrvgnd_1
XTAP_TAPCELL_ROW_45_362 VGND VPWR sky130_fd_sc_hd__tapvpwrvgnd_1
Xhold224 _0080_ VGND VGND VPWR VPWR net356 sky130_fd_sc_hd__dlygate4sd3_1
Xhold235 net55 VGND VGND VPWR VPWR net367 sky130_fd_sc_hd__dlygate4sd3_1
Xhold202 _0235_ VGND VGND VPWR VPWR net334 sky130_fd_sc_hd__dlygate4sd3_1
Xhold257 product_reg\[12\] VGND VGND VPWR VPWR net389 sky130_fd_sc_hd__dlygate4sd3_1
Xhold246 net59 VGND VGND VPWR VPWR net378 sky130_fd_sc_hd__dlygate4sd3_1
XFILLER_44_197 VGND VGND VPWR VPWR sky130_fd_sc_hd__decap_8
XFILLER_44_164 VPWR VGND VPWR VGND sky130_ef_sc_hd__decap_12
XFILLER_44_153 VGND VGND VPWR VPWR sky130_fd_sc_hd__fill_1
XTAP_TAPCELL_ROW_42_343 VGND VPWR sky130_fd_sc_hd__tapvpwrvgnd_1
XFILLER_4_282 VGND VGND VPWR VPWR sky130_fd_sc_hd__decap_3
X_1383_ clknet_3_3__leaf_clk _0009_ VGND VGND VPWR VPWR net67 sky130_fd_sc_hd__dfxtp_1
XFILLER_35_153 VPWR VGND VPWR VGND sky130_ef_sc_hd__decap_12
Xrebuffer94 net308 VGND VGND VPWR VPWR net226 sky130_fd_sc_hd__buf_6
Xrebuffer50 _0110_ VGND VGND VPWR VPWR net182 sky130_fd_sc_hd__dlygate4sd1_1
Xrebuffer83 _0406_ VGND VGND VPWR VPWR net215 sky130_fd_sc_hd__buf_1
XFILLER_41_167 VGND VGND VPWR VPWR sky130_fd_sc_hd__fill_1
Xrebuffer173 _0293_ VGND VGND VPWR VPWR net305 sky130_fd_sc_hd__dlygate4sd1_1
XFILLER_17_131 VGND VGND VPWR VPWR sky130_fd_sc_hd__decap_3
X_0952_ net329 _0283_ VGND VGND VPWR VPWR _0285_ sky130_fd_sc_hd__xnor2_1
X_0883_ net79 _0230_ _0229_ VGND VGND VPWR VPWR _0031_ sky130_fd_sc_hd__nor3b_1
X_1366_ net220 net81 VGND VGND VPWR VPWR _0059_ sky130_fd_sc_hd__and2_1
X_1435_ clknet_3_0__leaf_clk _0061_ VGND VGND VPWR VPWR net31 sky130_fd_sc_hd__dfxtp_1
X_1297_ _0595_ _0591_ _0594_ VGND VGND VPWR VPWR _0623_ sky130_fd_sc_hd__o21ai_1
XFILLER_52_85 VPWR VGND VPWR VGND sky130_ef_sc_hd__decap_12
XFILLER_52_41 VPWR VGND VPWR VGND sky130_ef_sc_hd__decap_12
XFILLER_14_178 VGND VGND VPWR VPWR sky130_fd_sc_hd__fill_2
Xinput17 net316 VGND VGND VPWR VPWR net17 sky130_fd_sc_hd__clkbuf_2
X_1220_ _0537_ _0539_ _0546_ VGND VGND VPWR VPWR _0548_ sky130_fd_sc_hd__nand3b_2
X_1151_ net2 net112 VGND VGND VPWR VPWR _0480_ sky130_fd_sc_hd__nand2_1
XFILLER_45_281 VPWR VGND VPWR VGND sky130_ef_sc_hd__decap_12
X_1082_ net104 net124 net101 net120 VGND VGND VPWR VPWR _0412_ sky130_fd_sc_hd__nand4_4
X_0866_ net72 net74 _0216_ VGND VGND VPWR VPWR _0218_ sky130_fd_sc_hd__and3_1
X_0935_ _0264_ _0266_ _0267_ VGND VGND VPWR VPWR _0268_ sky130_fd_sc_hd__nand3_2
XFILLER_9_193 VPWR VGND VPWR VGND sky130_ef_sc_hd__decap_12
XTAP_TAPCELL_ROW_15_195 VGND VPWR sky130_fd_sc_hd__tapvpwrvgnd_1
X_0797_ product_reg\[12\] net40 VGND VGND VPWR VPWR _0163_ sky130_fd_sc_hd__or2_1
X_1349_ _0647_ _0648_ _0665_ _0667_ VGND VGND VPWR VPWR _0672_ sky130_fd_sc_hd__nor4_2
X_1418_ clknet_3_1__leaf_clk _0044_ VGND VGND VPWR VPWR product_reg\[1\] sky130_fd_sc_hd__dfxtp_4
XFILLER_51_295 VGND VGND VPWR VPWR sky130_fd_sc_hd__decap_6
XFILLER_11_126 VPWR VGND VPWR VGND sky130_ef_sc_hd__decap_12
XFILLER_34_207 VPWR VGND VPWR VGND sky130_ef_sc_hd__decap_12
XFILLER_27_281 VGND VGND VPWR VPWR sky130_fd_sc_hd__decap_4
X_0720_ product_reg\[2\] net59 VGND VGND VPWR VPWR _0096_ sky130_fd_sc_hd__nor2_1
XFILLER_8_57 VGND VGND VPWR VPWR sky130_fd_sc_hd__fill_2
XFILLER_6_141 VGND VGND VPWR VPWR sky130_fd_sc_hd__decap_6
XFILLER_10_192 VGND VGND VPWR VPWR sky130_fd_sc_hd__decap_4
X_1203_ _0525_ _0528_ _0524_ VGND VGND VPWR VPWR _0531_ sky130_fd_sc_hd__o21bai_2
X_1134_ net10 net127 net222 net91 VGND VGND VPWR VPWR _0463_ sky130_fd_sc_hd__nand4_4
XFILLER_26_3 VGND VGND VPWR VPWR sky130_fd_sc_hd__decap_6
X_1065_ net127 net98 VGND VGND VPWR VPWR _0395_ sky130_fd_sc_hd__nand2_2
XFILLER_25_207 VGND VGND VPWR VPWR sky130_fd_sc_hd__fill_1
XFILLER_25_218 VGND VGND VPWR VPWR sky130_fd_sc_hd__decap_6
X_0918_ _0239_ net131 net127 _0237_ VGND VGND VPWR VPWR _0252_ sky130_fd_sc_hd__a31o_1
X_0849_ net49 net280 _0204_ net80 _0206_ VGND VGND VPWR VPWR _0021_ sky130_fd_sc_hd__a311oi_1
XTAP_TAPCELL_ROW_26_257 VGND VPWR sky130_fd_sc_hd__tapvpwrvgnd_1
XFILLER_47_310 VGND VGND VPWR VPWR sky130_fd_sc_hd__fill_1
XFILLER_30_232 VGND VGND VPWR VPWR sky130_fd_sc_hd__fill_2
X_0703_ net17 net18 VGND VGND VPWR VPWR _0083_ sky130_fd_sc_hd__or2_1
XTAP_TAPCELL_ROW_0_114 VGND VPWR sky130_fd_sc_hd__tapvpwrvgnd_1
X_1117_ _0440_ _0443_ _0375_ VGND VGND VPWR VPWR _0447_ sky130_fd_sc_hd__nand3_1
XPHY_EDGE_ROW_3_Right_3 VGND VGND VPWR VPWR sky130_fd_sc_hd__decap_3
X_1048_ _0374_ _0320_ _0376_ VGND VGND VPWR VPWR _0379_ sky130_fd_sc_hd__nand3_4
XTAP_TAPCELL_ROW_23_238 VGND VPWR sky130_fd_sc_hd__tapvpwrvgnd_1
XTAP_TAPCELL_ROW_31_282 VGND VPWR sky130_fd_sc_hd__tapvpwrvgnd_1
XFILLER_0_125 VGND VGND VPWR VPWR sky130_fd_sc_hd__decap_4
XFILLER_0_147 VGND VGND VPWR VPWR sky130_fd_sc_hd__decap_8
XFILLER_0_169 VGND VGND VPWR VPWR sky130_fd_sc_hd__fill_2
XFILLER_44_97 VPWR VGND VPWR VGND sky130_ef_sc_hd__decap_12
XFILLER_8_203 VGND VGND VPWR VPWR sky130_fd_sc_hd__fill_1
XFILLER_8_269 VGND VGND VPWR VPWR sky130_fd_sc_hd__fill_1
XFILLER_5_47 VGND VGND VPWR VPWR sky130_fd_sc_hd__fill_2
XFILLER_47_140 VGND VGND VPWR VPWR sky130_fd_sc_hd__fill_1
XTAP_TAPCELL_ROW_37_319 VGND VPWR sky130_fd_sc_hd__tapvpwrvgnd_1
XTAP_TAPCELL_ROW_45_363 VGND VPWR sky130_fd_sc_hd__tapvpwrvgnd_1
Xhold214 _0077_ VGND VGND VPWR VPWR net346 sky130_fd_sc_hd__dlygate4sd3_1
Xhold247 net219 VGND VGND VPWR VPWR net379 sky130_fd_sc_hd__dlygate4sd3_1
Xhold225 net119 VGND VGND VPWR VPWR net357 sky130_fd_sc_hd__dlygate4sd3_1
Xhold258 _0291_ VGND VGND VPWR VPWR net390 sky130_fd_sc_hd__dlygate4sd3_1
Xhold236 net44 VGND VGND VPWR VPWR net368 sky130_fd_sc_hd__dlygate4sd3_1
XFILLER_38_195 VGND VGND VPWR VPWR sky130_fd_sc_hd__fill_1
XFILLER_5_206 VGND VGND VPWR VPWR sky130_fd_sc_hd__decap_8
XFILLER_14_23 VGND VGND VPWR VPWR sky130_fd_sc_hd__fill_2
XFILLER_30_22 VGND VGND VPWR VPWR sky130_fd_sc_hd__fill_2
XFILLER_44_121 VGND VGND VPWR VPWR sky130_fd_sc_hd__decap_8
XFILLER_44_176 VGND VGND VPWR VPWR sky130_fd_sc_hd__decap_8
XTAP_TAPCELL_ROW_42_344 VGND VPWR sky130_fd_sc_hd__tapvpwrvgnd_1
XFILLER_32_305 VGND VGND VPWR VPWR sky130_fd_sc_hd__decap_3
X_1382_ clknet_3_2__leaf_clk _0008_ VGND VGND VPWR VPWR net66 sky130_fd_sc_hd__dfxtp_1
XFILLER_35_165 VGND VGND VPWR VPWR sky130_fd_sc_hd__decap_3
XFILLER_41_113 VGND VGND VPWR VPWR sky130_fd_sc_hd__fill_1
Xrebuffer40 _0141_ VGND VGND VPWR VPWR net172 sky130_fd_sc_hd__dlymetal6s2s_1
Xrebuffer84 _0498_ VGND VGND VPWR VPWR net216 sky130_fd_sc_hd__buf_6
XFILLER_41_87 VGND VGND VPWR VPWR sky130_fd_sc_hd__decap_4
Xrebuffer174 _0289_ VGND VGND VPWR VPWR net306 sky130_fd_sc_hd__dlygate4sd1_1
XFILLER_2_15 VPWR VGND VPWR VGND sky130_ef_sc_hd__decap_12
XFILLER_1_220 VGND VGND VPWR VPWR sky130_fd_sc_hd__decap_4
X_0882_ _0226_ net58 net60 VGND VGND VPWR VPWR _0230_ sky130_fd_sc_hd__and3_1
XFILLER_32_168 VPWR VGND VPWR VGND sky130_ef_sc_hd__decap_12
XFILLER_32_157 VGND VGND VPWR VPWR sky130_fd_sc_hd__decap_6
X_0951_ _0256_ _0257_ _0282_ _0242_ VGND VGND VPWR VPWR _0284_ sky130_fd_sc_hd__nand4_4
X_1365_ _0678_ _0683_ net325 _0686_ VGND VGND VPWR VPWR _0058_ sky130_fd_sc_hd__a31oi_1
X_1296_ _0616_ _0618_ _0620_ VGND VGND VPWR VPWR _0622_ sky130_fd_sc_hd__nand3b_1
X_1434_ clknet_3_0__leaf_clk _0060_ VGND VGND VPWR VPWR net30 sky130_fd_sc_hd__dfxtp_1
XFILLER_11_308 VGND VGND VPWR VPWR sky130_fd_sc_hd__decap_3
XFILLER_11_35 VGND VGND VPWR VPWR sky130_fd_sc_hd__fill_1
XFILLER_46_205 VGND VGND VPWR VPWR sky130_fd_sc_hd__fill_1
XFILLER_52_97 VPWR VGND VPWR VGND sky130_ef_sc_hd__decap_12
XFILLER_52_53 VGND VGND VPWR VPWR sky130_fd_sc_hd__decap_3
Xinput18 net314 VGND VGND VPWR VPWR net18 sky130_fd_sc_hd__clkbuf_2
X_1150_ net228 _0471_ _0405_ _0423_ _0474_ VGND VGND VPWR VPWR _0479_ sky130_fd_sc_hd__o221ai_4
XTAP_TAPCELL_ROW_9_161 VGND VPWR sky130_fd_sc_hd__tapvpwrvgnd_1
XFILLER_45_293 VPWR VGND VPWR VGND sky130_ef_sc_hd__decap_12
XFILLER_45_260 VPWR VGND VPWR VGND sky130_ef_sc_hd__decap_12
X_1081_ net104 net124 net101 net120 VGND VGND VPWR VPWR _0411_ sky130_fd_sc_hd__and4_1
X_0865_ _0215_ _0217_ net84 VGND VGND VPWR VPWR _0026_ sky130_fd_sc_hd__and3_1
X_0934_ net103 net88 net308 net102 VGND VGND VPWR VPWR _0267_ sky130_fd_sc_hd__nand4_4
XTAP_TAPCELL_ROW_15_196 VGND VPWR sky130_fd_sc_hd__tapvpwrvgnd_1
XFILLER_20_138 VGND VGND VPWR VPWR sky130_fd_sc_hd__fill_2
X_1417_ clknet_3_1__leaf_clk _0043_ VGND VGND VPWR VPWR product_reg\[0\] sky130_fd_sc_hd__dfxtp_2
X_0796_ _0161_ _0070_ _0160_ _0162_ net84 VGND VGND VPWR VPWR _0012_ sky130_fd_sc_hd__o311a_1
X_1279_ _0576_ _0579_ VGND VGND VPWR VPWR _0605_ sky130_fd_sc_hd__nand2_1
X_1348_ _0669_ _0670_ net78 _0671_ VGND VGND VPWR VPWR _0056_ sky130_fd_sc_hd__a31oi_1
XFILLER_11_138 VPWR VGND VPWR VGND sky130_ef_sc_hd__decap_12
XFILLER_42_263 VGND VGND VPWR VPWR sky130_fd_sc_hd__decap_8
XFILLER_42_241 VGND VGND VPWR VPWR sky130_fd_sc_hd__fill_1
XFILLER_34_219 VPWR VGND VPWR VGND sky130_ef_sc_hd__decap_12
XTAP_TAPCELL_ROW_12_177 VGND VPWR sky130_fd_sc_hd__tapvpwrvgnd_1
XFILLER_6_197 VPWR VGND VPWR VGND sky130_ef_sc_hd__decap_12
XFILLER_6_175 VGND VGND VPWR VPWR sky130_fd_sc_hd__decap_3
X_1202_ _0076_ _0078_ _0526_ _0529_ VGND VGND VPWR VPWR _0530_ sky130_fd_sc_hd__o211ai_2
X_1133_ net10 net127 net227 net91 VGND VGND VPWR VPWR _0462_ sky130_fd_sc_hd__and4_1
X_1064_ _0326_ _0327_ _0331_ VGND VGND VPWR VPWR _0394_ sky130_fd_sc_hd__o21a_4
X_0917_ _0249_ net109 net127 _0247_ VGND VGND VPWR VPWR _0251_ sky130_fd_sc_hd__nand4_2
X_0779_ _0145_ _0146_ _0147_ VGND VGND VPWR VPWR _0148_ sky130_fd_sc_hd__a21oi_1
X_0848_ net279 _0204_ net351 VGND VGND VPWR VPWR _0206_ sky130_fd_sc_hd__a21oi_2
XTAP_TAPCELL_ROW_26_258 VGND VPWR sky130_fd_sc_hd__tapvpwrvgnd_1
XFILLER_3_178 VPWR VGND VPWR VGND sky130_ef_sc_hd__decap_12
XFILLER_3_134 VGND VGND VPWR VPWR sky130_fd_sc_hd__fill_2
XFILLER_30_288 VGND VGND VPWR VPWR sky130_fd_sc_hd__decap_4
X_0702_ net17 net18 VGND VGND VPWR VPWR _0082_ sky130_fd_sc_hd__nor2_1
XTAP_TAPCELL_ROW_0_115 VGND VPWR sky130_fd_sc_hd__tapvpwrvgnd_1
X_1047_ _0374_ _0376_ _0320_ VGND VGND VPWR VPWR _0378_ sky130_fd_sc_hd__a21o_1
X_1116_ _0440_ _0375_ VGND VGND VPWR VPWR _0446_ sky130_fd_sc_hd__nand2_2
XTAP_TAPCELL_ROW_31_283 VGND VPWR sky130_fd_sc_hd__tapvpwrvgnd_1
XFILLER_9_90 VPWR VGND VPWR VGND sky130_ef_sc_hd__decap_12
XTAP_TAPCELL_ROW_23_239 VGND VPWR sky130_fd_sc_hd__tapvpwrvgnd_1
XFILLER_5_15 VPWR VGND VPWR VGND sky130_ef_sc_hd__decap_12
XFILLER_12_277 VGND VGND VPWR VPWR sky130_fd_sc_hd__decap_4
XFILLER_47_163 VGND VGND VPWR VPWR sky130_fd_sc_hd__fill_1
XPHY_EDGE_ROW_13_Right_13 VGND VGND VPWR VPWR sky130_fd_sc_hd__decap_3
XPHY_EDGE_ROW_22_Right_22 VGND VGND VPWR VPWR sky130_fd_sc_hd__decap_3
Xhold237 net58 VGND VGND VPWR VPWR net369 sky130_fd_sc_hd__dlygate4sd3_1
Xhold215 _0074_ VGND VGND VPWR VPWR net347 sky130_fd_sc_hd__dlygate4sd3_1
Xhold259 product_reg\[2\] VGND VGND VPWR VPWR net391 sky130_fd_sc_hd__dlygate4sd3_1
Xhold204 _0274_ VGND VGND VPWR VPWR net336 sky130_fd_sc_hd__dlygate4sd3_1
Xhold226 net123 VGND VGND VPWR VPWR net358 sky130_fd_sc_hd__dlygate4sd3_1
Xhold248 net210 VGND VGND VPWR VPWR net380 sky130_fd_sc_hd__dlygate4sd3_1
XFILLER_38_141 VPWR VGND VPWR VGND sky130_ef_sc_hd__decap_12
XPHY_EDGE_ROW_31_Right_31 VGND VGND VPWR VPWR sky130_fd_sc_hd__decap_3
XPHY_EDGE_ROW_40_Right_40 VGND VGND VPWR VPWR sky130_fd_sc_hd__decap_3
XFILLER_39_65 VGND VGND VPWR VPWR sky130_fd_sc_hd__decap_4
XFILLER_29_152 VPWR VGND VPWR VGND sky130_ef_sc_hd__decap_12
XTAP_TAPCELL_ROW_42_345 VGND VPWR sky130_fd_sc_hd__tapvpwrvgnd_1
X_1381_ clknet_3_2__leaf_clk _0007_ VGND VGND VPWR VPWR net65 sky130_fd_sc_hd__dfxtp_1
XFILLER_35_111 VGND VGND VPWR VPWR sky130_fd_sc_hd__fill_1
Xrebuffer30 net163 VGND VGND VPWR VPWR net162 sky130_fd_sc_hd__dlygate4sd1_1
XFILLER_26_133 VGND VGND VPWR VPWR sky130_fd_sc_hd__decap_6
Xrebuffer41 _0153_ VGND VGND VPWR VPWR net173 sky130_fd_sc_hd__buf_6
Xrebuffer85 net95 VGND VGND VPWR VPWR net217 sky130_fd_sc_hd__buf_2
XFILLER_41_169 VGND VGND VPWR VPWR sky130_fd_sc_hd__decap_4
Xrebuffer74 _0468_ VGND VGND VPWR VPWR net206 sky130_fd_sc_hd__dlymetal6s2s_1
Xrebuffer96 _0467_ VGND VGND VPWR VPWR net228 sky130_fd_sc_hd__buf_4
XFILLER_1_210 VGND VGND VPWR VPWR sky130_fd_sc_hd__decap_3
Xrebuffer175 _0302_ VGND VGND VPWR VPWR net307 sky130_fd_sc_hd__buf_4
XFILLER_49_225 VGND VGND VPWR VPWR sky130_fd_sc_hd__decap_8
XFILLER_49_203 VGND VGND VPWR VPWR sky130_fd_sc_hd__decap_8
XFILLER_2_27 VGND VGND VPWR VPWR sky130_fd_sc_hd__fill_1
X_0881_ net58 net57 _0224_ net60 VGND VGND VPWR VPWR _0229_ sky130_fd_sc_hd__a31o_1
X_0950_ _0281_ _0282_ VGND VGND VPWR VPWR _0283_ sky130_fd_sc_hd__nand2_1
XFILLER_20_309 VGND VGND VPWR VPWR sky130_fd_sc_hd__fill_2
X_1433_ clknet_3_0__leaf_clk _0059_ VGND VGND VPWR VPWR net29 sky130_fd_sc_hd__dfxtp_1
X_1364_ product_reg\[15\] _0084_ net84 VGND VGND VPWR VPWR _0686_ sky130_fd_sc_hd__o21ai_1
X_1295_ _0616_ _0617_ _0620_ VGND VGND VPWR VPWR _0621_ sky130_fd_sc_hd__o21bai_1
XFILLER_23_169 VGND VGND VPWR VPWR sky130_fd_sc_hd__decap_8
XPHY_EDGE_ROW_52_Left_105 VGND VGND VPWR VPWR sky130_fd_sc_hd__decap_3
XFILLER_36_99 VGND VGND VPWR VPWR sky130_fd_sc_hd__decap_4
XFILLER_36_33 VPWR VGND VPWR VGND sky130_ef_sc_hd__decap_12
XFILLER_36_11 VGND VGND VPWR VPWR sky130_fd_sc_hd__fill_1
Xinput19 net320 VGND VGND VPWR VPWR net19 sky130_fd_sc_hd__clkbuf_2
XFILLER_14_158 VPWR VGND VPWR VGND sky130_ef_sc_hd__decap_12
XTAP_TAPCELL_ROW_9_162 VGND VPWR sky130_fd_sc_hd__tapvpwrvgnd_1
XFILLER_37_206 VGND VGND VPWR VPWR sky130_fd_sc_hd__fill_2
X_1080_ net124 net101 net120 net104 VGND VGND VPWR VPWR _0410_ sky130_fd_sc_hd__a22o_1
XFILLER_45_272 VGND VGND VPWR VPWR sky130_fd_sc_hd__decap_8
X_0864_ v_pipe net288 net74 _0216_ VGND VGND VPWR VPWR _0217_ sky130_fd_sc_hd__nand4_1
X_0795_ net77 net39 VGND VGND VPWR VPWR _0162_ sky130_fd_sc_hd__or2_1
X_0933_ net103 net308 net102 net88 VGND VGND VPWR VPWR _0266_ sky130_fd_sc_hd__a22o_4
XFILLER_9_151 VGND VGND VPWR VPWR sky130_fd_sc_hd__decap_3
XTAP_TAPCELL_ROW_15_197 VGND VPWR sky130_fd_sc_hd__tapvpwrvgnd_1
X_1416_ clknet_3_5__leaf_clk _0042_ VGND VGND VPWR VPWR net28 sky130_fd_sc_hd__dfxtp_1
X_1347_ product_reg\[13\] net78 net85 VGND VGND VPWR VPWR _0671_ sky130_fd_sc_hd__o21ai_1
XFILLER_3_81 VPWR VGND VPWR VGND sky130_ef_sc_hd__decap_12
X_1278_ _0604_ _0602_ net344 _0232_ VGND VGND VPWR VPWR _0053_ sky130_fd_sc_hd__a2bb2o_4
XPHY_EDGE_ROW_5_Left_58 VGND VGND VPWR VPWR sky130_fd_sc_hd__decap_3
Xfanout130 net10 VGND VGND VPWR VPWR net130 sky130_fd_sc_hd__buf_12
XFILLER_8_15 VPWR VGND VPWR VGND sky130_ef_sc_hd__decap_12
XFILLER_6_165 VGND VGND VPWR VPWR sky130_fd_sc_hd__decap_3
XFILLER_10_183 VGND VGND VPWR VPWR sky130_fd_sc_hd__fill_1
XTAP_TAPCELL_ROW_12_178 VGND VPWR sky130_fd_sc_hd__tapvpwrvgnd_1
X_1201_ net125 net121 net217 net99 VGND VGND VPWR VPWR _0529_ sky130_fd_sc_hd__nand4_4
X_1132_ net127 net91 VGND VGND VPWR VPWR _0461_ sky130_fd_sc_hd__nand2_2
X_1063_ _0326_ net154 _0331_ VGND VGND VPWR VPWR _0393_ sky130_fd_sc_hd__o21ai_4
X_0916_ net126 net109 _0247_ _0249_ VGND VGND VPWR VPWR _0250_ sky130_fd_sc_hd__a22o_1
X_0778_ _0138_ _0144_ VGND VGND VPWR VPWR _0147_ sky130_fd_sc_hd__and2_1
X_0847_ _0203_ _0205_ net83 VGND VGND VPWR VPWR _0020_ sky130_fd_sc_hd__and3_1
XFILLER_17_57 VGND VGND VPWR VPWR sky130_fd_sc_hd__decap_8
XTAP_TAPCELL_ROW_26_259 VGND VPWR sky130_fd_sc_hd__tapvpwrvgnd_1
XFILLER_3_113 VGND VGND VPWR VPWR sky130_fd_sc_hd__decap_3
XFILLER_15_297 VGND VGND VPWR VPWR sky130_fd_sc_hd__fill_2
X_0701_ net113 VGND VGND VPWR VPWR _0081_ sky130_fd_sc_hd__inv_2
XFILLER_31_3 VGND VGND VPWR VPWR sky130_fd_sc_hd__decap_8
XTAP_TAPCELL_ROW_0_116 VGND VPWR sky130_fd_sc_hd__tapvpwrvgnd_1
X_1046_ _0374_ _0376_ VGND VGND VPWR VPWR _0377_ sky130_fd_sc_hd__nand2_1
X_1115_ _0440_ _0443_ _0375_ VGND VGND VPWR VPWR _0445_ sky130_fd_sc_hd__a21oi_4
XTAP_TAPCELL_ROW_31_284 VGND VPWR sky130_fd_sc_hd__tapvpwrvgnd_1
XFILLER_21_223 VGND VGND VPWR VPWR sky130_fd_sc_hd__fill_1
XFILLER_48_109 VGND VGND VPWR VPWR sky130_fd_sc_hd__decap_6
XFILLER_28_78 VGND VGND VPWR VPWR sky130_fd_sc_hd__decap_6
XFILLER_44_22 VGND VGND VPWR VPWR sky130_fd_sc_hd__decap_6
XFILLER_5_27 VPWR VGND VPWR VGND sky130_ef_sc_hd__decap_12
XFILLER_12_289 VGND VGND VPWR VPWR sky130_fd_sc_hd__fill_1
XPHY_EDGE_ROW_8_Left_61 VGND VGND VPWR VPWR sky130_fd_sc_hd__decap_3
Xhold238 net61 VGND VGND VPWR VPWR net370 sky130_fd_sc_hd__dlygate4sd3_1
Xhold249 net54 VGND VGND VPWR VPWR net381 sky130_fd_sc_hd__dlygate4sd3_1
Xhold216 _0073_ VGND VGND VPWR VPWR net348 sky130_fd_sc_hd__dlygate4sd3_1
Xhold227 product_reg\[4\] VGND VGND VPWR VPWR net359 sky130_fd_sc_hd__dlygate4sd3_1
XFILLER_38_153 VPWR VGND VPWR VGND sky130_ef_sc_hd__decap_12
XTAP_TAPCELL_ROW_36_310 VGND VPWR sky130_fd_sc_hd__tapvpwrvgnd_1
X_1029_ _0353_ _0355_ _0357_ VGND VGND VPWR VPWR _0360_ sky130_fd_sc_hd__and3_1
XFILLER_30_57 VPWR VGND VPWR VGND sky130_ef_sc_hd__decap_12
XPHY_EDGE_ROW_34_Left_87 VGND VGND VPWR VPWR sky130_fd_sc_hd__decap_3
XFILLER_29_164 VGND VGND VPWR VPWR sky130_fd_sc_hd__decap_4
XTAP_TAPCELL_ROW_50_390 VGND VPWR sky130_fd_sc_hd__tapvpwrvgnd_1
XTAP_TAPCELL_ROW_42_346 VGND VPWR sky130_fd_sc_hd__tapvpwrvgnd_1
XFILLER_4_241 VGND VGND VPWR VPWR sky130_fd_sc_hd__decap_3
X_1380_ clknet_3_2__leaf_clk _0006_ VGND VGND VPWR VPWR net64 sky130_fd_sc_hd__dfxtp_1
XFILLER_35_101 VGND VGND VPWR VPWR sky130_fd_sc_hd__decap_3
Xrebuffer86 net90 VGND VGND VPWR VPWR net218 sky130_fd_sc_hd__dlygate4sd1_1
Xrebuffer75 _0397_ VGND VGND VPWR VPWR net207 sky130_fd_sc_hd__buf_1
Xrebuffer42 _0396_ VGND VGND VPWR VPWR net174 sky130_fd_sc_hd__buf_6
Xrebuffer97 _0479_ VGND VGND VPWR VPWR net229 sky130_fd_sc_hd__buf_2
Xrebuffer31 net171 VGND VGND VPWR VPWR net163 sky130_fd_sc_hd__dlymetal6s4s_1
XFILLER_14_307 VGND VGND VPWR VPWR sky130_fd_sc_hd__fill_1
Xrebuffer20 _0327_ VGND VGND VPWR VPWR net152 sky130_fd_sc_hd__clkbuf_2
XFILLER_25_57 VPWR VGND VPWR VGND sky130_ef_sc_hd__decap_12
XFILLER_9_3 VPWR VGND VPWR VGND sky130_ef_sc_hd__decap_12
Xrebuffer176 net128 VGND VGND VPWR VPWR net308 sky130_fd_sc_hd__buf_8
XFILLER_17_123 VGND VGND VPWR VPWR sky130_fd_sc_hd__decap_8
X_0880_ net58 _0226_ net85 _0228_ VGND VGND VPWR VPWR _0030_ sky130_fd_sc_hd__o211a_1
X_1432_ clknet_3_4__leaf_clk _0058_ VGND VGND VPWR VPWR product_reg\[15\] sky130_fd_sc_hd__dfxtp_1
X_1363_ _0080_ net87 net324 net19 net20 VGND VGND VPWR VPWR _0685_ sky130_fd_sc_hd__o311a_1
X_1294_ net362 net115 _0526_ _0571_ _0619_ VGND VGND VPWR VPWR _0620_ sky130_fd_sc_hd__a41o_1
XFILLER_11_15 VPWR VGND VPWR VGND sky130_ef_sc_hd__decap_12
XFILLER_39_281 VPWR VGND VPWR VGND sky130_ef_sc_hd__decap_12
XFILLER_14_126 VGND VGND VPWR VPWR sky130_fd_sc_hd__decap_4
XFILLER_22_181 VGND VGND VPWR VPWR sky130_fd_sc_hd__decap_8
XTAP_TAPCELL_ROW_9_163 VGND VPWR sky130_fd_sc_hd__tapvpwrvgnd_1
XPHY_EDGE_ROW_37_Left_90 VGND VGND VPWR VPWR sky130_fd_sc_hd__decap_3
X_0932_ net226 net103 net102 net88 VGND VGND VPWR VPWR _0265_ sky130_fd_sc_hd__a22oi_4
XFILLER_13_181 VGND VGND VPWR VPWR sky130_fd_sc_hd__decap_4
XTAP_TAPCELL_ROW_15_198 VGND VPWR sky130_fd_sc_hd__tapvpwrvgnd_1
XFILLER_20_129 VGND VGND VPWR VPWR sky130_fd_sc_hd__decap_4
X_0863_ net54 net53 net52 VGND VGND VPWR VPWR _0216_ sky130_fd_sc_hd__and3_1
XPHY_EDGE_ROW_21_Left_74 VGND VGND VPWR VPWR sky130_fd_sc_hd__decap_3
X_0794_ _0151_ _0155_ _0157_ _0158_ VGND VGND VPWR VPWR _0161_ sky130_fd_sc_hd__a22oi_1
X_1346_ _0649_ _0655_ _0668_ VGND VGND VPWR VPWR _0670_ sky130_fd_sc_hd__nand3_1
X_1415_ clknet_3_3__leaf_clk _0041_ VGND VGND VPWR VPWR net27 sky130_fd_sc_hd__dfxtp_1
XFILLER_28_207 VGND VGND VPWR VPWR sky130_fd_sc_hd__fill_1
X_1277_ _0567_ _0569_ _0601_ _0086_ VGND VGND VPWR VPWR _0604_ sky130_fd_sc_hd__a31o_1
Xfanout131 net132 VGND VGND VPWR VPWR net131 sky130_fd_sc_hd__buf_2
Xfanout120 net122 VGND VGND VPWR VPWR net120 sky130_fd_sc_hd__clkbuf_8
XTAP_TAPCELL_ROW_6_144 VGND VPWR sky130_fd_sc_hd__tapvpwrvgnd_1
XFILLER_27_251 VGND VGND VPWR VPWR sky130_fd_sc_hd__decap_4
XFILLER_42_221 VPWR VGND VPWR VGND sky130_ef_sc_hd__decap_12
XFILLER_8_27 VGND VGND VPWR VPWR sky130_fd_sc_hd__fill_1
XFILLER_10_173 VGND VGND VPWR VPWR sky130_fd_sc_hd__fill_2
XTAP_TAPCELL_ROW_12_179 VGND VPWR sky130_fd_sc_hd__tapvpwrvgnd_1
X_1200_ net124 net121 net217 net99 VGND VGND VPWR VPWR _0528_ sky130_fd_sc_hd__and4_1
X_1131_ net127 net94 net91 net10 VGND VGND VPWR VPWR _0460_ sky130_fd_sc_hd__a22o_2
X_1062_ _0388_ _0389_ VGND VGND VPWR VPWR _0392_ sky130_fd_sc_hd__nor2_2
X_0915_ net103 net219 net210 net106 VGND VGND VPWR VPWR _0249_ sky130_fd_sc_hd__a22o_1
XFILLER_0_309 VGND VGND VPWR VPWR sky130_fd_sc_hd__fill_2
X_0846_ net71 _0204_ VGND VGND VPWR VPWR _0205_ sky130_fd_sc_hd__nand2_4
X_0777_ product_reg\[9\] net68 VGND VGND VPWR VPWR _0146_ sky130_fd_sc_hd__or2_1
X_1329_ _0598_ _0624_ _0625_ VGND VGND VPWR VPWR _0654_ sky130_fd_sc_hd__o21ai_2
XFILLER_33_57 VGND VGND VPWR VPWR sky130_fd_sc_hd__decap_4
XFILLER_47_302 VGND VGND VPWR VPWR sky130_fd_sc_hd__decap_8
XTAP_TAPCELL_ROW_17_205 VGND VPWR sky130_fd_sc_hd__tapvpwrvgnd_1
X_0700_ net92 VGND VGND VPWR VPWR _0080_ sky130_fd_sc_hd__inv_2
XFILLER_30_224 VGND VGND VPWR VPWR sky130_fd_sc_hd__decap_8
XFILLER_38_302 VGND VGND VPWR VPWR sky130_fd_sc_hd__fill_1
XTAP_TAPCELL_ROW_0_106 VGND VPWR sky130_fd_sc_hd__tapvpwrvgnd_1
X_1114_ _0436_ _0441_ _0440_ VGND VGND VPWR VPWR _0444_ sky130_fd_sc_hd__o21a_1
XFILLER_24_3 VPWR VGND VPWR VGND sky130_ef_sc_hd__decap_12
XFILLER_0_83 VGND VGND VPWR VPWR sky130_fd_sc_hd__fill_1
X_1045_ _0360_ _0373_ _0372_ _0323_ VGND VGND VPWR VPWR _0376_ sky130_fd_sc_hd__o211ai_4
X_0829_ _0189_ _0190_ _0191_ net85 VGND VGND VPWR VPWR _0016_ sky130_fd_sc_hd__o211a_1
XTAP_TAPCELL_ROW_31_285 VGND VPWR sky130_fd_sc_hd__tapvpwrvgnd_1
XTAP_TAPCELL_ROW_39_330 VGND VPWR sky130_fd_sc_hd__tapvpwrvgnd_1
XFILLER_28_57 VGND VGND VPWR VPWR sky130_fd_sc_hd__fill_1
XFILLER_44_56 VPWR VGND VPWR VGND sky130_ef_sc_hd__decap_12
XFILLER_8_239 VPWR VGND VPWR VGND sky130_ef_sc_hd__decap_12
XFILLER_5_39 VGND VGND VPWR VPWR sky130_fd_sc_hd__decap_8
XFILLER_47_121 VGND VGND VPWR VPWR sky130_fd_sc_hd__fill_1
Xhold239 net41 VGND VGND VPWR VPWR net371 sky130_fd_sc_hd__dlygate4sd3_1
Xhold228 net37 VGND VGND VPWR VPWR net360 sky130_fd_sc_hd__dlygate4sd3_1
XPHY_EDGE_ROW_7_Right_7 VGND VGND VPWR VPWR sky130_fd_sc_hd__decap_3
XFILLER_38_165 VPWR VGND VPWR VGND sky130_ef_sc_hd__decap_12
XFILLER_38_121 VPWR VGND VPWR VGND sky130_ef_sc_hd__decap_12
XTAP_TAPCELL_ROW_36_311 VGND VPWR sky130_fd_sc_hd__tapvpwrvgnd_1
XFILLER_41_308 VGND VGND VPWR VPWR sky130_fd_sc_hd__decap_3
XFILLER_14_15 VGND VGND VPWR VPWR sky130_fd_sc_hd__decap_8
X_1028_ _0351_ _0356_ _0352_ VGND VGND VPWR VPWR _0359_ sky130_fd_sc_hd__nand3_4
XFILLER_30_47 VGND VGND VPWR VPWR sky130_fd_sc_hd__decap_3
XFILLER_30_69 VPWR VGND VPWR VGND sky130_ef_sc_hd__decap_12
XFILLER_29_110 VGND VGND VPWR VPWR sky130_fd_sc_hd__fill_2
XTAP_TAPCELL_ROW_50_391 VGND VPWR sky130_fd_sc_hd__tapvpwrvgnd_1
XTAP_TAPCELL_ROW_42_347 VGND VPWR sky130_fd_sc_hd__tapvpwrvgnd_1
XFILLER_50_149 VGND VGND VPWR VPWR sky130_fd_sc_hd__decap_3
XFILLER_50_116 VGND VGND VPWR VPWR sky130_fd_sc_hd__decap_4
XFILLER_41_138 VGND VGND VPWR VPWR sky130_fd_sc_hd__decap_4
Xrebuffer98 _0479_ VGND VGND VPWR VPWR net230 sky130_fd_sc_hd__dlymetal6s2s_1
Xrebuffer32 _0103_ VGND VGND VPWR VPWR net164 sky130_fd_sc_hd__buf_6
Xrebuffer87 net90 VGND VGND VPWR VPWR net219 sky130_fd_sc_hd__dlygate4sd1_1
Xrebuffer21 net152 VGND VGND VPWR VPWR net153 sky130_fd_sc_hd__buf_1
XFILLER_25_69 VGND VGND VPWR VPWR sky130_fd_sc_hd__fill_1
Xrebuffer10 _0498_ VGND VGND VPWR VPWR net142 sky130_fd_sc_hd__buf_4
Xrebuffer43 _0407_ VGND VGND VPWR VPWR net175 sky130_fd_sc_hd__buf_1
Xrebuffer76 net215 VGND VGND VPWR VPWR net208 sky130_fd_sc_hd__dlygate4sd1_1
Xrebuffer144 net48 VGND VGND VPWR VPWR net276 sky130_fd_sc_hd__dlygate4sd1_1
Xrebuffer100 net231 VGND VGND VPWR VPWR net232 sky130_fd_sc_hd__buf_1
Xrebuffer155 _0196_ VGND VGND VPWR VPWR net287 sky130_fd_sc_hd__buf_1
XFILLER_1_267 VPWR VGND VPWR VGND sky130_ef_sc_hd__decap_12
XFILLER_1_234 VGND VGND VPWR VPWR sky130_fd_sc_hd__decap_4
Xrebuffer177 net129 VGND VGND VPWR VPWR net309 sky130_fd_sc_hd__buf_4
XFILLER_49_249 VPWR VGND VPWR VGND sky130_ef_sc_hd__decap_12
XFILLER_49_216 VGND VGND VPWR VPWR sky130_fd_sc_hd__decap_8
XFILLER_2_29 VPWR VGND VPWR VGND sky130_ef_sc_hd__decap_12
XFILLER_32_105 VGND VGND VPWR VPWR sky130_fd_sc_hd__fill_2
XFILLER_31_90 VGND VGND VPWR VPWR sky130_fd_sc_hd__decap_8
X_1293_ _0572_ net113 net105 VGND VGND VPWR VPWR _0619_ sky130_fd_sc_hd__and3_1
X_1431_ clknet_3_3__leaf_clk _0057_ VGND VGND VPWR VPWR product_reg\[14\] sky130_fd_sc_hd__dfxtp_1
X_1362_ _0067_ net317 net315 net78 _0684_ VGND VGND VPWR VPWR _0057_ sky130_fd_sc_hd__o41ai_1
XFILLER_11_27 VGND VGND VPWR VPWR sky130_fd_sc_hd__decap_8
XFILLER_39_293 VGND VGND VPWR VPWR sky130_fd_sc_hd__fill_1
XTAP_TAPCELL_ROW_9_164 VGND VPWR sky130_fd_sc_hd__tapvpwrvgnd_1
X_0862_ net53 net52 net280 net74 net381 VGND VGND VPWR VPWR _0215_ sky130_fd_sc_hd__a41o_1
X_0931_ net106 net126 VGND VGND VPWR VPWR _0264_ sky130_fd_sc_hd__nand2_2
XFILLER_9_164 VGND VGND VPWR VPWR sky130_fd_sc_hd__decap_4
Xrebuffer1 _0477_ VGND VGND VPWR VPWR net133 sky130_fd_sc_hd__dlymetal6s2s_1
X_0793_ _0155_ _0151_ _0157_ _0158_ VGND VGND VPWR VPWR _0160_ sky130_fd_sc_hd__and4_1
X_1414_ clknet_3_5__leaf_clk _0040_ VGND VGND VPWR VPWR net26 sky130_fd_sc_hd__dfxtp_1
X_1345_ _0649_ _0655_ _0665_ _0667_ VGND VGND VPWR VPWR _0669_ sky130_fd_sc_hd__o2bb2ai_1
X_1276_ _0569_ _0567_ _0601_ VGND VGND VPWR VPWR _0603_ sky130_fd_sc_hd__a21o_1
XFILLER_51_211 VGND VGND VPWR VPWR sky130_fd_sc_hd__decap_4
XFILLER_36_285 VGND VGND VPWR VPWR sky130_fd_sc_hd__fill_2
XFILLER_22_26 VGND VGND VPWR VPWR sky130_fd_sc_hd__fill_2
Xfanout121 net122 VGND VGND VPWR VPWR net121 sky130_fd_sc_hd__clkbuf_4
Xfanout110 net2 VGND VGND VPWR VPWR net110 sky130_fd_sc_hd__buf_6
XTAP_TAPCELL_ROW_6_145 VGND VPWR sky130_fd_sc_hd__tapvpwrvgnd_1
Xfanout132 net1 VGND VGND VPWR VPWR net132 sky130_fd_sc_hd__buf_2
XFILLER_27_263 VPWR VGND VPWR VGND sky130_ef_sc_hd__decap_12
XFILLER_42_233 VGND VGND VPWR VPWR sky130_fd_sc_hd__decap_8
XFILLER_10_141 VPWR VGND VPWR VGND sky130_ef_sc_hd__decap_12
X_1130_ net127 net227 net91 net10 VGND VGND VPWR VPWR _0459_ sky130_fd_sc_hd__a22oi_2
XFILLER_18_263 VGND VGND VPWR VPWR sky130_fd_sc_hd__decap_3
XFILLER_18_274 VGND VGND VPWR VPWR sky130_fd_sc_hd__decap_3
X_1061_ _0384_ _0387_ net132 net112 VGND VGND VPWR VPWR _0391_ sky130_fd_sc_hd__o211a_1
X_0914_ net103 net88 net225 net106 VGND VGND VPWR VPWR _0248_ sky130_fd_sc_hd__a22oi_2
X_0845_ net47 net46 net45 net44 VGND VGND VPWR VPWR _0204_ sky130_fd_sc_hd__and4_1
X_0776_ product_reg\[9\] net68 VGND VGND VPWR VPWR _0145_ sky130_fd_sc_hd__nand2_1
X_1259_ _0463_ _0535_ _0580_ _0581_ VGND VGND VPWR VPWR _0586_ sky130_fd_sc_hd__o2bb2ai_4
XFILLER_17_48 VGND VGND VPWR VPWR sky130_fd_sc_hd__decap_8
X_1328_ _0566_ _0515_ _0652_ VGND VGND VPWR VPWR _0653_ sky130_fd_sc_hd__o21ai_4
XPHY_EDGE_ROW_49_Left_102 VGND VGND VPWR VPWR sky130_fd_sc_hd__decap_3
XFILLER_3_126 VGND VGND VPWR VPWR sky130_fd_sc_hd__decap_8
XFILLER_15_277 VGND VGND VPWR VPWR sky130_fd_sc_hd__decap_3
XTAP_TAPCELL_ROW_17_206 VGND VPWR sky130_fd_sc_hd__tapvpwrvgnd_1
XTAP_TAPCELL_ROW_25_250 VGND VPWR sky130_fd_sc_hd__tapvpwrvgnd_1
XFILLER_30_258 VPWR VGND VPWR VGND sky130_ef_sc_hd__decap_12
XTAP_TAPCELL_ROW_48_375 VGND VPWR sky130_fd_sc_hd__tapvpwrvgnd_1
XTAP_TAPCELL_ROW_0_107 VGND VPWR sky130_fd_sc_hd__tapvpwrvgnd_1
X_1044_ _0360_ _0373_ _0372_ _0323_ VGND VGND VPWR VPWR _0375_ sky130_fd_sc_hd__o211a_4
X_1113_ _0366_ _0437_ _0438_ VGND VGND VPWR VPWR _0443_ sky130_fd_sc_hd__nand3b_4
XFILLER_17_3 VGND VGND VPWR VPWR sky130_fd_sc_hd__fill_2
XFILLER_21_225 VPWR VGND VPWR VGND sky130_ef_sc_hd__decap_12
X_0828_ net77 net43 VGND VGND VPWR VPWR _0191_ sky130_fd_sc_hd__or2_1
XTAP_TAPCELL_ROW_31_286 VGND VPWR sky130_fd_sc_hd__tapvpwrvgnd_1
X_0759_ net75 net377 net82 _0130_ VGND VGND VPWR VPWR _0007_ sky130_fd_sc_hd__o211a_1
XFILLER_44_68 VPWR VGND VPWR VGND sky130_ef_sc_hd__decap_12
XFILLER_44_46 VGND VGND VPWR VPWR sky130_fd_sc_hd__decap_6
XFILLER_47_177 VGND VGND VPWR VPWR sky130_fd_sc_hd__decap_3
XFILLER_47_111 VGND VGND VPWR VPWR sky130_fd_sc_hd__fill_1
XFILLER_50_309 VGND VGND VPWR VPWR sky130_fd_sc_hd__fill_2
Xhold229 _0078_ VGND VGND VPWR VPWR net361 sky130_fd_sc_hd__dlygate4sd3_1
Xhold207 _0233_ VGND VGND VPWR VPWR net339 sky130_fd_sc_hd__dlygate4sd3_1
Xhold218 _0075_ VGND VGND VPWR VPWR net350 sky130_fd_sc_hd__dlygate4sd3_1
XFILLER_7_262 VGND VGND VPWR VPWR sky130_fd_sc_hd__decap_6
Xclkbuf_3_5__f_clk clknet_0_clk VGND VGND VPWR VPWR clknet_3_5__leaf_clk sky130_fd_sc_hd__clkbuf_16
XFILLER_38_177 VGND VGND VPWR VPWR sky130_fd_sc_hd__decap_4
XFILLER_38_133 VGND VGND VPWR VPWR sky130_fd_sc_hd__decap_6
XTAP_TAPCELL_ROW_36_312 VGND VPWR sky130_fd_sc_hd__tapvpwrvgnd_1
X_1027_ _0353_ _0355_ _0357_ VGND VGND VPWR VPWR _0358_ sky130_fd_sc_hd__a21oi_1
XFILLER_32_309 VGND VGND VPWR VPWR sky130_fd_sc_hd__fill_2
XFILLER_29_199 VGND VGND VPWR VPWR sky130_fd_sc_hd__fill_1
XFILLER_35_169 VPWR VGND VPWR VGND sky130_ef_sc_hd__decap_12
Xrebuffer11 _0339_ VGND VGND VPWR VPWR net143 sky130_fd_sc_hd__buf_2
Xrebuffer33 net97 VGND VGND VPWR VPWR net165 sky130_fd_sc_hd__dlygate4sd1_1
Xrebuffer77 net130 VGND VGND VPWR VPWR net209 sky130_fd_sc_hd__dlymetal6s2s_1
Xrebuffer88 net379 VGND VGND VPWR VPWR net220 sky130_fd_sc_hd__dlygate4sd1_1
XFILLER_14_309 VGND VGND VPWR VPWR sky130_fd_sc_hd__fill_2
Xrebuffer99 _0381_ VGND VGND VPWR VPWR net231 sky130_fd_sc_hd__buf_1
Xrebuffer22 _0327_ VGND VGND VPWR VPWR net154 sky130_fd_sc_hd__buf_6
XFILLER_25_15 VPWR VGND VPWR VGND sky130_ef_sc_hd__decap_12
Xrebuffer44 _0477_ VGND VGND VPWR VPWR net176 sky130_fd_sc_hd__buf_6
XFILLER_41_25 VGND VGND VPWR VPWR sky130_fd_sc_hd__fill_1
Xrebuffer156 _0196_ VGND VGND VPWR VPWR net288 sky130_fd_sc_hd__buf_1
Xrebuffer112 _0653_ VGND VGND VPWR VPWR net244 sky130_fd_sc_hd__clkbuf_1
Xrebuffer145 net276 VGND VGND VPWR VPWR net277 sky130_fd_sc_hd__dlygate4sd1_1
Xrebuffer178 net129 VGND VGND VPWR VPWR net310 sky130_fd_sc_hd__dlygate4sd1_1
Xrebuffer101 _0511_ VGND VGND VPWR VPWR net233 sky130_fd_sc_hd__buf_2
XFILLER_1_279 VGND VGND VPWR VPWR sky130_fd_sc_hd__fill_1
XFILLER_1_202 VGND VGND VPWR VPWR sky130_fd_sc_hd__decap_8
XFILLER_17_169 VGND VGND VPWR VPWR sky130_fd_sc_hd__fill_2
XFILLER_32_117 VGND VGND VPWR VPWR sky130_fd_sc_hd__fill_1
XFILLER_9_302 VGND VGND VPWR VPWR sky130_fd_sc_hd__fill_2
XFILLER_49_6 VPWR VGND VPWR VGND sky130_ef_sc_hd__decap_12
X_1430_ clknet_3_5__leaf_clk _0056_ VGND VGND VPWR VPWR product_reg\[13\] sky130_fd_sc_hd__dfxtp_1
X_1292_ _0613_ _0615_ _0586_ _0588_ VGND VGND VPWR VPWR _0618_ sky130_fd_sc_hd__o211ai_2
X_1361_ _0681_ _0676_ _0000_ _0682_ VGND VGND VPWR VPWR _0684_ sky130_fd_sc_hd__o211ai_2
XFILLER_31_194 VGND VGND VPWR VPWR sky130_fd_sc_hd__fill_2
XFILLER_52_57 VPWR VGND VPWR VGND sky130_ef_sc_hd__decap_12
XTAP_TAPCELL_ROW_9_165 VGND VPWR sky130_fd_sc_hd__tapvpwrvgnd_1
X_0861_ _0214_ _0213_ net84 VGND VGND VPWR VPWR _0025_ sky130_fd_sc_hd__and3_1
Xrebuffer2 _0477_ VGND VGND VPWR VPWR net134 sky130_fd_sc_hd__buf_6
X_0792_ _0155_ _0151_ _0158_ VGND VGND VPWR VPWR _0159_ sky130_fd_sc_hd__nand3_4
X_0930_ _0248_ _0246_ _0247_ VGND VGND VPWR VPWR _0263_ sky130_fd_sc_hd__o21a_1
XFILLER_9_110 VGND VGND VPWR VPWR sky130_fd_sc_hd__fill_2
XFILLER_20_109 VGND VGND VPWR VPWR sky130_fd_sc_hd__decap_3
X_1413_ clknet_3_5__leaf_clk _0039_ VGND VGND VPWR VPWR net25 sky130_fd_sc_hd__dfxtp_1
X_1344_ _0665_ _0667_ VGND VGND VPWR VPWR _0668_ sky130_fd_sc_hd__nor2_1
X_1275_ _0569_ _0567_ _0601_ VGND VGND VPWR VPWR _0602_ sky130_fd_sc_hd__a21oi_4
XFILLER_3_51 VGND VGND VPWR VPWR sky130_fd_sc_hd__decap_4
XFILLER_51_201 VGND VGND VPWR VPWR sky130_fd_sc_hd__fill_2
Xfanout100 net6 VGND VGND VPWR VPWR net100 sky130_fd_sc_hd__buf_4
XTAP_TAPCELL_ROW_6_146 VGND VPWR sky130_fd_sc_hd__tapvpwrvgnd_1
Xfanout111 net2 VGND VGND VPWR VPWR net111 sky130_fd_sc_hd__clkbuf_4
Xfanout122 net13 VGND VGND VPWR VPWR net122 sky130_fd_sc_hd__buf_2
XFILLER_27_275 VGND VGND VPWR VPWR sky130_fd_sc_hd__decap_4
XPHY_EDGE_ROW_29_Right_29 VGND VGND VPWR VPWR sky130_fd_sc_hd__decap_3
XPHY_EDGE_ROW_38_Right_38 VGND VGND VPWR VPWR sky130_fd_sc_hd__decap_3
XFILLER_8_29 VPWR VGND VPWR VGND sky130_ef_sc_hd__decap_12
XFILLER_10_131 VGND VGND VPWR VPWR sky130_fd_sc_hd__decap_8
XFILLER_10_153 VPWR VGND VPWR VGND sky130_ef_sc_hd__decap_12
XFILLER_10_197 VGND VGND VPWR VPWR sky130_fd_sc_hd__decap_3
XPHY_EDGE_ROW_47_Right_47 VGND VGND VPWR VPWR sky130_fd_sc_hd__decap_3
XFILLER_18_242 VGND VGND VPWR VPWR sky130_fd_sc_hd__fill_1
X_1060_ _0075_ net87 _0385_ _0386_ VGND VGND VPWR VPWR _0390_ sky130_fd_sc_hd__o211a_1
XFILLER_33_223 VGND VGND VPWR VPWR sky130_fd_sc_hd__fill_1
XTAP_TAPCELL_ROW_28_270 VGND VPWR sky130_fd_sc_hd__tapvpwrvgnd_1
X_0913_ net103 net219 net210 net106 VGND VGND VPWR VPWR _0247_ sky130_fd_sc_hd__nand4_2
X_0775_ net76 net374 _0142_ _0143_ net82 VGND VGND VPWR VPWR _0009_ sky130_fd_sc_hd__o221a_1
X_0844_ net71 net45 net44 net46 net383 VGND VGND VPWR VPWR _0203_ sky130_fd_sc_hd__a41o_1
X_1258_ _0329_ _0461_ _0535_ _0584_ VGND VGND VPWR VPWR _0585_ sky130_fd_sc_hd__o211ai_4
X_1189_ net341 _0232_ _0517_ _0516_ VGND VGND VPWR VPWR _0051_ sky130_fd_sc_hd__a22o_1
X_1327_ _0559_ _0568_ _0651_ VGND VGND VPWR VPWR _0652_ sky130_fd_sc_hd__a21oi_2
XFILLER_15_223 VGND VGND VPWR VPWR sky130_fd_sc_hd__fill_1
XTAP_TAPCELL_ROW_17_207 VGND VPWR sky130_fd_sc_hd__tapvpwrvgnd_1
XTAP_TAPCELL_ROW_25_251 VGND VPWR sky130_fd_sc_hd__tapvpwrvgnd_1
XFILLER_30_248 VGND VGND VPWR VPWR sky130_fd_sc_hd__decap_4
XFILLER_2_193 VGND VGND VPWR VPWR sky130_fd_sc_hd__decap_3
XTAP_TAPCELL_ROW_48_376 VGND VPWR sky130_fd_sc_hd__tapvpwrvgnd_1
XFILLER_0_41 VGND VGND VPWR VPWR sky130_fd_sc_hd__decap_8
XFILLER_0_63 VPWR VGND VPWR VGND sky130_ef_sc_hd__decap_12
XFILLER_0_85 VGND VGND VPWR VPWR sky130_fd_sc_hd__fill_2
XTAP_TAPCELL_ROW_0_108 VGND VPWR sky130_fd_sc_hd__tapvpwrvgnd_1
X_1043_ _0315_ _0318_ _0370_ _0371_ VGND VGND VPWR VPWR _0374_ sky130_fd_sc_hd__nand4_2
X_1112_ _0362_ _0437_ _0438_ _0364_ VGND VGND VPWR VPWR _0442_ sky130_fd_sc_hd__and4b_1
XFILLER_21_237 VGND VGND VPWR VPWR sky130_fd_sc_hd__decap_8
X_0827_ _0180_ _0185_ _0187_ _0188_ _0070_ VGND VGND VPWR VPWR _0190_ sky130_fd_sc_hd__a41o_1
X_0758_ _0127_ _0128_ net76 VGND VGND VPWR VPWR _0130_ sky130_fd_sc_hd__o21ai_1
X_0689_ product_reg\[5\] VGND VGND VPWR VPWR _0069_ sky130_fd_sc_hd__inv_2
XFILLER_28_26 VGND VGND VPWR VPWR sky130_fd_sc_hd__fill_2
XTAP_TAPCELL_ROW_22_232 VGND VPWR sky130_fd_sc_hd__tapvpwrvgnd_1
XFILLER_47_167 VGND VGND VPWR VPWR sky130_fd_sc_hd__fill_1
XFILLER_11_281 VGND VGND VPWR VPWR sky130_fd_sc_hd__decap_3
Xhold208 product_reg\[9\] VGND VGND VPWR VPWR net340 sky130_fd_sc_hd__dlygate4sd3_1
Xhold219 net49 VGND VGND VPWR VPWR net351 sky130_fd_sc_hd__dlygate4sd3_1
XTAP_TAPCELL_ROW_36_313 VGND VPWR sky130_fd_sc_hd__tapvpwrvgnd_1
X_1026_ _0295_ _0307_ _0309_ VGND VGND VPWR VPWR _0357_ sky130_fd_sc_hd__o21ai_4
XFILLER_44_137 VGND VGND VPWR VPWR sky130_fd_sc_hd__decap_3
XFILLER_4_266 VGND VGND VPWR VPWR sky130_fd_sc_hd__decap_6
XFILLER_29_80 VGND VGND VPWR VPWR sky130_fd_sc_hd__fill_1
Xrebuffer34 net165 VGND VGND VPWR VPWR net166 sky130_fd_sc_hd__dlygate4sd1_1
Xrebuffer23 _0396_ VGND VGND VPWR VPWR net155 sky130_fd_sc_hd__buf_6
Xrebuffer12 _0339_ VGND VGND VPWR VPWR net144 sky130_fd_sc_hd__buf_6
Xrebuffer45 _0430_ VGND VGND VPWR VPWR net177 sky130_fd_sc_hd__buf_6
Xrebuffer89 net90 VGND VGND VPWR VPWR net221 sky130_fd_sc_hd__dlygate4sd1_1
Xrebuffer78 net130 VGND VGND VPWR VPWR net210 sky130_fd_sc_hd__dlygate4sd1_1
X_1009_ net111 net116 VGND VGND VPWR VPWR _0340_ sky130_fd_sc_hd__nand2_1
XFILLER_25_27 VGND VGND VPWR VPWR sky130_fd_sc_hd__fill_1
Xrebuffer102 net95 VGND VGND VPWR VPWR net234 sky130_fd_sc_hd__dlygate4sd1_1
Xrebuffer179 net310 VGND VGND VPWR VPWR net311 sky130_fd_sc_hd__dlymetal6s2s_1
Xrebuffer146 net48 VGND VGND VPWR VPWR net278 sky130_fd_sc_hd__dlygate4sd1_1
Xoutput70 net70 VGND VGND VPWR VPWR v_b_out sky130_fd_sc_hd__buf_2
X_1360_ _0674_ _0673_ _0680_ _0679_ VGND VGND VPWR VPWR _0683_ sky130_fd_sc_hd__o2bb2ai_1
X_1291_ _0613_ _0615_ _0586_ _0588_ VGND VGND VPWR VPWR _0617_ sky130_fd_sc_hd__o211a_1
XTAP_TAPCELL_ROW_52_400 VGND VPWR sky130_fd_sc_hd__tapvpwrvgnd_1
XFILLER_52_69 VPWR VGND VPWR VGND sky130_ef_sc_hd__decap_12
XFILLER_7_3 VPWR VGND VPWR VGND sky130_ef_sc_hd__decap_12
XFILLER_26_70 VPWR VGND VPWR VGND sky130_ef_sc_hd__decap_12
X_0860_ net72 net52 net53 net74 VGND VGND VPWR VPWR _0214_ sky130_fd_sc_hd__nand4_4
X_0791_ product_reg\[11\] net39 VGND VGND VPWR VPWR _0158_ sky130_fd_sc_hd__nand2_1
Xrebuffer3 _0477_ VGND VGND VPWR VPWR net135 sky130_fd_sc_hd__dlymetal6s2s_1
XFILLER_9_177 VGND VGND VPWR VPWR sky130_fd_sc_hd__fill_1
X_1343_ _0666_ VGND VGND VPWR VPWR _0667_ sky130_fd_sc_hd__inv_2
X_1412_ clknet_3_0__leaf_clk _0038_ VGND VGND VPWR VPWR net24 sky130_fd_sc_hd__dfxtp_1
X_1274_ _0598_ _0599_ VGND VGND VPWR VPWR _0601_ sky130_fd_sc_hd__or2_1
XFILLER_3_96 VPWR VGND VPWR VGND sky130_ef_sc_hd__decap_12
XTAP_TAPCELL_ROW_14_190 VGND VPWR sky130_fd_sc_hd__tapvpwrvgnd_1
XFILLER_3_309 VGND VGND VPWR VPWR sky130_fd_sc_hd__fill_2
X_0989_ _0281_ _0284_ _0319_ VGND VGND VPWR VPWR _0321_ sky130_fd_sc_hd__a21o_1
Xfanout101 net5 VGND VGND VPWR VPWR net101 sky130_fd_sc_hd__clkbuf_8
Xfanout112 net16 VGND VGND VPWR VPWR net112 sky130_fd_sc_hd__clkbuf_4
XTAP_TAPCELL_ROW_6_147 VGND VPWR sky130_fd_sc_hd__tapvpwrvgnd_1
Xfanout123 net125 VGND VGND VPWR VPWR net123 sky130_fd_sc_hd__buf_6
XFILLER_27_298 VGND VGND VPWR VPWR sky130_fd_sc_hd__fill_1
XFILLER_10_110 VGND VGND VPWR VPWR sky130_fd_sc_hd__decap_6
XFILLER_10_165 VGND VGND VPWR VPWR sky130_fd_sc_hd__decap_8
XFILLER_12_83 VGND VGND VPWR VPWR sky130_fd_sc_hd__fill_1
XPHY_EDGE_ROW_25_Left_78 VGND VGND VPWR VPWR sky130_fd_sc_hd__decap_3
XFILLER_26_9 VGND VGND VPWR VPWR sky130_fd_sc_hd__fill_1
X_0912_ net126 net110 VGND VGND VPWR VPWR _0246_ sky130_fd_sc_hd__nand2_1
X_0843_ _0202_ _0201_ net83 VGND VGND VPWR VPWR _0019_ sky130_fd_sc_hd__and3_1
X_0774_ product_reg\[7\] net66 _0138_ _0141_ _0139_ VGND VGND VPWR VPWR _0144_ sky130_fd_sc_hd__o2111ai_4
X_1326_ _0600_ _0624_ _0625_ VGND VGND VPWR VPWR _0651_ sky130_fd_sc_hd__o21ai_1
XTAP_TAPCELL_ROW_3_128 VGND VPWR sky130_fd_sc_hd__tapvpwrvgnd_1
X_1257_ _0582_ _0583_ VGND VGND VPWR VPWR _0584_ sky130_fd_sc_hd__nand2_1
X_1188_ _0512_ _0515_ net86 net78 VGND VGND VPWR VPWR _0517_ sky130_fd_sc_hd__o211a_1
XTAP_TAPCELL_ROW_17_208 VGND VPWR sky130_fd_sc_hd__tapvpwrvgnd_1
XTAP_TAPCELL_ROW_25_252 VGND VPWR sky130_fd_sc_hd__tapvpwrvgnd_1
XTAP_TAPCELL_ROW_48_377 VGND VPWR sky130_fd_sc_hd__tapvpwrvgnd_1
XFILLER_0_75 VGND VGND VPWR VPWR sky130_fd_sc_hd__decap_8
XTAP_TAPCELL_ROW_0_109 VGND VPWR sky130_fd_sc_hd__tapvpwrvgnd_1
X_1042_ _0351_ _0356_ _0352_ _0369_ VGND VGND VPWR VPWR _0373_ sky130_fd_sc_hd__a31o_1
X_1111_ _0438_ _0364_ net114 net388 VGND VGND VPWR VPWR _0441_ sky130_fd_sc_hd__nand4_1
X_0826_ _0180_ _0185_ _0187_ _0188_ VGND VGND VPWR VPWR _0189_ sky130_fd_sc_hd__a22oi_1
X_0757_ product_reg\[5\] net64 _0126_ _0125_ VGND VGND VPWR VPWR _0129_ sky130_fd_sc_hd__o211ai_2
X_0688_ product_reg\[7\] VGND VGND VPWR VPWR _0068_ sky130_fd_sc_hd__inv_2
X_1309_ _0611_ _0633_ VGND VGND VPWR VPWR _0634_ sky130_fd_sc_hd__nand2_1
XFILLER_44_37 VGND VGND VPWR VPWR sky130_fd_sc_hd__fill_2
XTAP_TAPCELL_ROW_22_233 VGND VPWR sky130_fd_sc_hd__tapvpwrvgnd_1
XFILLER_47_113 VGND VGND VPWR VPWR sky130_fd_sc_hd__decap_8
XFILLER_47_135 VGND VGND VPWR VPWR sky130_fd_sc_hd__fill_2
Xhold209 product_reg\[8\] VGND VGND VPWR VPWR net341 sky130_fd_sc_hd__dlygate4sd3_1
XTAP_TAPCELL_ROW_36_314 VGND VPWR sky130_fd_sc_hd__tapvpwrvgnd_1
XFILLER_14_29 VGND VGND VPWR VPWR sky130_fd_sc_hd__fill_2
X_1025_ _0295_ _0307_ _0309_ VGND VGND VPWR VPWR _0356_ sky130_fd_sc_hd__o21a_4
XPHY_EDGE_ROW_28_Left_81 VGND VGND VPWR VPWR sky130_fd_sc_hd__decap_3
X_0809_ product_reg\[13\] net41 VGND VGND VPWR VPWR _0174_ sky130_fd_sc_hd__and2_1
XPHY_EDGE_ROW_12_Left_65 VGND VGND VPWR VPWR sky130_fd_sc_hd__decap_3
XFILLER_30_39 VGND VGND VPWR VPWR sky130_fd_sc_hd__decap_8
XFILLER_17_308 VGND VGND VPWR VPWR sky130_fd_sc_hd__decap_3
XFILLER_52_182 VGND VGND VPWR VPWR sky130_fd_sc_hd__decap_3
XFILLER_20_83 VGND VGND VPWR VPWR sky130_fd_sc_hd__fill_1
XFILLER_45_91 VPWR VGND VPWR VGND sky130_ef_sc_hd__decap_12
XFILLER_6_41 VGND VGND VPWR VPWR sky130_fd_sc_hd__fill_2
Xrebuffer35 net165 VGND VGND VPWR VPWR net167 sky130_fd_sc_hd__dlygate4sd1_1
Xrebuffer13 _0536_ VGND VGND VPWR VPWR net145 sky130_fd_sc_hd__dlymetal6s2s_1
Xrebuffer24 _0398_ VGND VGND VPWR VPWR net156 sky130_fd_sc_hd__dlymetal6s2s_1
Xrebuffer79 net380 VGND VGND VPWR VPWR net211 sky130_fd_sc_hd__dlygate4sd1_1
Xrebuffer46 _0126_ VGND VGND VPWR VPWR net178 sky130_fd_sc_hd__dlymetal6s2s_1
XFILLER_34_182 VPWR VGND VPWR VGND sky130_ef_sc_hd__decap_12
X_1008_ net152 _0335_ _0324_ net307 _0334_ VGND VGND VPWR VPWR _0339_ sky130_fd_sc_hd__o221ai_4
Xrebuffer103 _0509_ VGND VGND VPWR VPWR net235 sky130_fd_sc_hd__clkbuf_2
Xrebuffer158 _0314_ VGND VGND VPWR VPWR net290 sky130_fd_sc_hd__buf_6
XFILLER_40_174 VGND VGND VPWR VPWR sky130_fd_sc_hd__decap_4
XFILLER_40_141 VGND VGND VPWR VPWR sky130_fd_sc_hd__decap_8
XFILLER_40_130 VGND VGND VPWR VPWR sky130_fd_sc_hd__decap_8
XFILLER_31_60 VPWR VGND VPWR VGND sky130_ef_sc_hd__decap_12
XFILLER_15_94 VGND VGND VPWR VPWR sky130_fd_sc_hd__fill_1
Xoutput60 net60 VGND VGND VPWR VPWR psum[30] sky130_fd_sc_hd__buf_2
XFILLER_48_241 VGND VGND VPWR VPWR sky130_fd_sc_hd__decap_8
X_1290_ _0614_ _0609_ _0587_ _0586_ _0613_ VGND VGND VPWR VPWR _0616_ sky130_fd_sc_hd__a221oi_4
XFILLER_0_281 VPWR VGND VPWR VGND sky130_ef_sc_hd__decap_12
XFILLER_31_174 VPWR VGND VPWR VGND sky130_ef_sc_hd__decap_12
XFILLER_39_252 VPWR VGND VPWR VGND sky130_ef_sc_hd__decap_12
XTAP_TAPCELL_ROW_52_401 VGND VPWR sky130_fd_sc_hd__tapvpwrvgnd_1
XFILLER_52_15 VPWR VGND VPWR VGND sky130_ef_sc_hd__decap_12
XFILLER_39_274 VGND VGND VPWR VPWR sky130_fd_sc_hd__decap_6
XFILLER_22_141 VGND VGND VPWR VPWR sky130_fd_sc_hd__decap_6
XFILLER_26_82 VGND VGND VPWR VPWR sky130_fd_sc_hd__fill_2
X_0790_ product_reg\[11\] net39 VGND VGND VPWR VPWR _0157_ sky130_fd_sc_hd__or2_1
Xrebuffer4 _0476_ VGND VGND VPWR VPWR net136 sky130_fd_sc_hd__dlymetal6s2s_1
X_1342_ _0615_ _0638_ _0639_ _0644_ _0664_ VGND VGND VPWR VPWR _0666_ sky130_fd_sc_hd__a311o_1
X_1273_ _0551_ _0554_ _0596_ _0597_ VGND VGND VPWR VPWR _0600_ sky130_fd_sc_hd__o211ai_1
X_1411_ clknet_3_0__leaf_clk _0037_ VGND VGND VPWR VPWR net23 sky130_fd_sc_hd__dfxtp_1
XFILLER_51_225 VPWR VGND VPWR VGND sky130_ef_sc_hd__decap_12
XFILLER_36_277 VGND VGND VPWR VPWR sky130_fd_sc_hd__decap_8
X_0988_ _0284_ _0281_ _0319_ VGND VGND VPWR VPWR _0320_ sky130_fd_sc_hd__a21oi_4
XTAP_TAPCELL_ROW_14_191 VGND VPWR sky130_fd_sc_hd__tapvpwrvgnd_1
XFILLER_22_29 VGND VGND VPWR VPWR sky130_fd_sc_hd__fill_2
Xfanout113 net16 VGND VGND VPWR VPWR net113 sky130_fd_sc_hd__buf_2
Xfanout102 net5 VGND VGND VPWR VPWR net102 sky130_fd_sc_hd__buf_4
Xfanout124 net125 VGND VGND VPWR VPWR net124 sky130_fd_sc_hd__buf_6
XFILLER_47_15 VGND VGND VPWR VPWR sky130_fd_sc_hd__fill_2
XTAP_TAPCELL_ROW_6_148 VGND VPWR sky130_fd_sc_hd__tapvpwrvgnd_1
XFILLER_50_291 VGND VGND VPWR VPWR sky130_fd_sc_hd__fill_1
XPHY_EDGE_ROW_0_Left_53 VGND VGND VPWR VPWR sky130_fd_sc_hd__decap_3
XFILLER_33_225 VPWR VGND VPWR VGND sky130_ef_sc_hd__decap_12
X_0911_ net131 net123 VGND VGND VPWR VPWR _0245_ sky130_fd_sc_hd__nand2_1
X_0842_ net71 net45 net44 net46 VGND VGND VPWR VPWR _0202_ sky130_fd_sc_hd__nand4_4
XFILLER_52_3 VPWR VGND VPWR VGND sky130_ef_sc_hd__decap_12
XFILLER_5_181 VGND VGND VPWR VPWR sky130_fd_sc_hd__decap_8
XTAP_TAPCELL_ROW_11_172 VGND VPWR sky130_fd_sc_hd__tapvpwrvgnd_1
X_0773_ _0132_ _0140_ _0141_ _0070_ VGND VGND VPWR VPWR _0143_ sky130_fd_sc_hd__a31o_1
X_1256_ _0578_ _0579_ net98 net117 VGND VGND VPWR VPWR _0583_ sky130_fd_sc_hd__nand4_1
X_1325_ _0647_ _0648_ VGND VGND VPWR VPWR _0650_ sky130_fd_sc_hd__nor2_1
XTAP_TAPCELL_ROW_3_129 VGND VPWR sky130_fd_sc_hd__tapvpwrvgnd_1
X_1187_ _0509_ _0511_ _0514_ VGND VGND VPWR VPWR _0516_ sky130_fd_sc_hd__a21o_1
XFILLER_24_258 VPWR VGND VPWR VGND sky130_ef_sc_hd__decap_12
XPHY_EDGE_ROW_42_Left_95 VGND VGND VPWR VPWR sky130_fd_sc_hd__decap_3
XFILLER_15_203 VPWR VGND VPWR VGND sky130_ef_sc_hd__decap_12
XFILLER_15_225 VPWR VGND VPWR VGND sky130_ef_sc_hd__decap_12
XTAP_TAPCELL_ROW_17_209 VGND VPWR sky130_fd_sc_hd__tapvpwrvgnd_1
XFILLER_15_269 VGND VGND VPWR VPWR sky130_fd_sc_hd__decap_8
XTAP_TAPCELL_ROW_25_253 VGND VPWR sky130_fd_sc_hd__tapvpwrvgnd_1
X_1110_ _0437_ _0438_ net343 _0365_ VGND VGND VPWR VPWR _0440_ sky130_fd_sc_hd__o2bb2ai_4
XTAP_TAPCELL_ROW_48_378 VGND VPWR sky130_fd_sc_hd__tapvpwrvgnd_1
X_1041_ _0359_ _0361_ _0366_ _0367_ VGND VGND VPWR VPWR _0372_ sky130_fd_sc_hd__a22o_4
X_0825_ product_reg\[15\] net43 VGND VGND VPWR VPWR _0188_ sky130_fd_sc_hd__nand2_1
X_0756_ _0119_ _0126_ _0125_ VGND VGND VPWR VPWR _0128_ sky130_fd_sc_hd__and3_1
X_0687_ net396 VGND VGND VPWR VPWR _0067_ sky130_fd_sc_hd__inv_2
X_1308_ net165 net115 VGND VGND VPWR VPWR _0633_ sky130_fd_sc_hd__nand2_1
XFILLER_44_309 VGND VGND VPWR VPWR sky130_fd_sc_hd__fill_2
X_1239_ _0509_ _0511_ _0559_ _0561_ VGND VGND VPWR VPWR _0566_ sky130_fd_sc_hd__nand4_4
XTAP_TAPCELL_ROW_22_234 VGND VPWR sky130_fd_sc_hd__tapvpwrvgnd_1
XFILLER_47_169 VGND VGND VPWR VPWR sky130_fd_sc_hd__decap_8
XFILLER_47_147 VGND VGND VPWR VPWR sky130_fd_sc_hd__fill_1
XTAP_TAPCELL_ROW_45_359 VGND VPWR sky130_fd_sc_hd__tapvpwrvgnd_1
XFILLER_7_298 VGND VGND VPWR VPWR sky130_fd_sc_hd__fill_1
XFILLER_15_3 VGND VGND VPWR VPWR sky130_fd_sc_hd__decap_8
X_1024_ _0341_ _0347_ _0345_ _0337_ net144 VGND VGND VPWR VPWR _0355_ sky130_fd_sc_hd__o2111ai_4
XFILLER_26_309 VGND VGND VPWR VPWR sky130_fd_sc_hd__fill_2
X_0808_ product_reg\[13\] net41 VGND VGND VPWR VPWR _0173_ sky130_fd_sc_hd__or2_1
X_0739_ _0111_ _0112_ VGND VGND VPWR VPWR _0113_ sky130_fd_sc_hd__nand2_1
XFILLER_29_169 VPWR VGND VPWR VGND sky130_ef_sc_hd__decap_12
XFILLER_20_40 VPWR VGND VPWR VGND sky130_ef_sc_hd__decap_12
XFILLER_43_172 VPWR VGND VPWR VGND sky130_ef_sc_hd__decap_12
XTAP_TAPCELL_ROW_41_340 VGND VPWR sky130_fd_sc_hd__tapvpwrvgnd_1
Xrebuffer36 net167 VGND VGND VPWR VPWR net168 sky130_fd_sc_hd__dlygate4sd1_1
Xrebuffer14 _0396_ VGND VGND VPWR VPWR net146 sky130_fd_sc_hd__dlymetal6s2s_1
Xrebuffer25 _0602_ VGND VGND VPWR VPWR net157 sky130_fd_sc_hd__clkbuf_2
Xrebuffer47 net178 VGND VGND VPWR VPWR net179 sky130_fd_sc_hd__dlygate4sd1_1
X_1007_ net307 _0324_ _0332_ _0333_ VGND VGND VPWR VPWR _0338_ sky130_fd_sc_hd__a2bb2oi_2
XFILLER_19_191 VPWR VGND VPWR VGND sky130_ef_sc_hd__decap_12
XFILLER_26_139 VGND VGND VPWR VPWR sky130_fd_sc_hd__fill_1
XFILLER_34_194 VGND VGND VPWR VPWR sky130_fd_sc_hd__fill_2
Xrebuffer104 _0430_ VGND VGND VPWR VPWR net236 sky130_fd_sc_hd__buf_6
XFILLER_1_238 VGND VGND VPWR VPWR sky130_fd_sc_hd__fill_1
Xrebuffer159 _0308_ VGND VGND VPWR VPWR net291 sky130_fd_sc_hd__clkbuf_1
XFILLER_25_150 VGND VGND VPWR VPWR sky130_fd_sc_hd__decap_4
XFILLER_31_72 VGND VGND VPWR VPWR sky130_fd_sc_hd__fill_1
Xoutput61 net61 VGND VGND VPWR VPWR psum[31] sky130_fd_sc_hd__buf_2
Xoutput50 net50 VGND VGND VPWR VPWR psum[21] sky130_fd_sc_hd__buf_2
XFILLER_48_297 VGND VGND VPWR VPWR sky130_fd_sc_hd__decap_6
XFILLER_48_253 VPWR VGND VPWR VGND sky130_ef_sc_hd__decap_12
XFILLER_0_293 VPWR VGND VPWR VGND sky130_ef_sc_hd__decap_12
XFILLER_23_109 VGND VGND VPWR VPWR sky130_fd_sc_hd__decap_3
XFILLER_31_186 VGND VGND VPWR VPWR sky130_fd_sc_hd__decap_8
XFILLER_31_164 VGND VGND VPWR VPWR sky130_fd_sc_hd__decap_4
XFILLER_39_264 VGND VGND VPWR VPWR sky130_fd_sc_hd__fill_2
XTAP_TAPCELL_ROW_52_402 VGND VPWR sky130_fd_sc_hd__tapvpwrvgnd_1
XFILLER_52_27 VGND VGND VPWR VPWR sky130_fd_sc_hd__fill_1
XFILLER_22_131 VGND VGND VPWR VPWR sky130_fd_sc_hd__fill_1
XFILLER_45_223 VGND VGND VPWR VPWR sky130_fd_sc_hd__fill_1
XFILLER_9_102 VGND VGND VPWR VPWR sky130_fd_sc_hd__decap_8
XFILLER_9_113 VPWR VGND VPWR VGND sky130_ef_sc_hd__decap_12
Xrebuffer5 net180 VGND VGND VPWR VPWR net137 sky130_fd_sc_hd__buf_1
X_1410_ clknet_3_0__leaf_clk _0036_ VGND VGND VPWR VPWR net22 sky130_fd_sc_hd__dfxtp_1
X_1341_ _0640_ _0644_ _0664_ VGND VGND VPWR VPWR _0665_ sky130_fd_sc_hd__o21a_1
X_1272_ _0570_ _0596_ _0597_ VGND VGND VPWR VPWR _0599_ sky130_fd_sc_hd__and3_1
XFILLER_51_237 VPWR VGND VPWR VGND sky130_ef_sc_hd__decap_12
X_0987_ _0318_ net290 _0317_ VGND VGND VPWR VPWR _0319_ sky130_fd_sc_hd__o21ai_4
XTAP_TAPCELL_ROW_14_192 VGND VPWR sky130_fd_sc_hd__tapvpwrvgnd_1
Xfanout114 net15 VGND VGND VPWR VPWR net114 sky130_fd_sc_hd__buf_4
Xfanout125 net12 VGND VGND VPWR VPWR net125 sky130_fd_sc_hd__buf_4
XTAP_TAPCELL_ROW_6_149 VGND VPWR sky130_fd_sc_hd__tapvpwrvgnd_1
Xfanout103 net105 VGND VGND VPWR VPWR net103 sky130_fd_sc_hd__buf_4
XFILLER_27_223 VGND VGND VPWR VPWR sky130_fd_sc_hd__fill_1
XFILLER_12_63 VGND VGND VPWR VPWR sky130_fd_sc_hd__decap_3
XFILLER_12_74 VGND VGND VPWR VPWR sky130_fd_sc_hd__decap_3
Xhold190 product_reg\[6\] VGND VGND VPWR VPWR net322 sky130_fd_sc_hd__dlygate4sd3_1
XFILLER_33_259 VPWR VGND VPWR VGND sky130_ef_sc_hd__decap_12
XFILLER_33_237 VGND VGND VPWR VPWR sky130_fd_sc_hd__fill_1
XPHY_EDGE_ROW_16_Right_16 VGND VGND VPWR VPWR sky130_fd_sc_hd__decap_3
XFILLER_41_281 VGND VGND VPWR VPWR sky130_fd_sc_hd__decap_3
X_0910_ net391 net82 _0085_ _0244_ VGND VGND VPWR VPWR _0045_ sky130_fd_sc_hd__a31o_1
XTAP_TAPCELL_ROW_11_173 VGND VPWR sky130_fd_sc_hd__tapvpwrvgnd_1
X_0772_ _0132_ net172 _0140_ VGND VGND VPWR VPWR _0142_ sky130_fd_sc_hd__a21oi_1
X_0841_ net45 net279 net44 net46 VGND VGND VPWR VPWR _0201_ sky130_fd_sc_hd__a31o_1
XPHY_EDGE_ROW_25_Right_25 VGND VGND VPWR VPWR sky130_fd_sc_hd__decap_3
X_1255_ net98 net117 _0578_ _0579_ VGND VGND VPWR VPWR _0582_ sky130_fd_sc_hd__a22o_1
X_1324_ _0646_ _0645_ VGND VGND VPWR VPWR _0649_ sky130_fd_sc_hd__nand2b_1
XPHY_EDGE_ROW_34_Right_34 VGND VGND VPWR VPWR sky130_fd_sc_hd__decap_3
X_1186_ _0375_ _0444_ _0513_ VGND VGND VPWR VPWR _0515_ sky130_fd_sc_hd__o21ai_2
XTAP_TAPCELL_ROW_34_298 VGND VPWR sky130_fd_sc_hd__tapvpwrvgnd_1
XFILLER_32_281 VPWR VGND VPWR VGND sky130_ef_sc_hd__decap_12
XFILLER_24_226 VPWR VGND VPWR VGND sky130_ef_sc_hd__decap_12
XPHY_EDGE_ROW_43_Right_43 VGND VGND VPWR VPWR sky130_fd_sc_hd__decap_3
XFILLER_3_108 VGND VGND VPWR VPWR sky130_fd_sc_hd__decap_4
XPHY_EDGE_ROW_52_Right_52 VGND VGND VPWR VPWR sky130_fd_sc_hd__decap_3
XFILLER_15_215 VGND VGND VPWR VPWR sky130_fd_sc_hd__decap_8
XFILLER_15_237 VGND VGND VPWR VPWR sky130_fd_sc_hd__fill_1
XFILLER_23_40 VGND VGND VPWR VPWR sky130_fd_sc_hd__decap_4
XFILLER_23_281 VGND VGND VPWR VPWR sky130_fd_sc_hd__decap_3
XFILLER_2_141 VPWR VGND VPWR VGND sky130_ef_sc_hd__decap_12
XFILLER_48_81 VGND VGND VPWR VPWR sky130_fd_sc_hd__decap_3
XFILLER_38_307 VGND VGND VPWR VPWR sky130_fd_sc_hd__fill_1
XFILLER_2_185 VGND VGND VPWR VPWR sky130_fd_sc_hd__decap_8
X_1040_ _0359_ _0361_ _0369_ VGND VGND VPWR VPWR _0371_ sky130_fd_sc_hd__nand3_1
XTAP_TAPCELL_ROW_48_379 VGND VPWR sky130_fd_sc_hd__tapvpwrvgnd_1
XFILLER_0_55 VGND VGND VPWR VPWR sky130_fd_sc_hd__fill_1
X_0824_ product_reg\[15\] net43 VGND VGND VPWR VPWR _0187_ sky130_fd_sc_hd__or2_1
X_0755_ _0119_ net179 _0125_ VGND VGND VPWR VPWR _0127_ sky130_fd_sc_hd__a21oi_1
XFILLER_28_29 VGND VGND VPWR VPWR sky130_fd_sc_hd__fill_1
X_1307_ net165 net387 VGND VGND VPWR VPWR _0632_ sky130_fd_sc_hd__and2_1
X_1238_ net340 _0232_ _0565_ VGND VGND VPWR VPWR _0052_ sky130_fd_sc_hd__a21o_1
X_1169_ _0493_ _0497_ _0491_ VGND VGND VPWR VPWR _0498_ sky130_fd_sc_hd__nand3_4
XTAP_TAPCELL_ROW_22_235 VGND VPWR sky130_fd_sc_hd__tapvpwrvgnd_1
Xclkbuf_3_0__f_clk clknet_0_clk VGND VGND VPWR VPWR clknet_3_0__leaf_clk sky130_fd_sc_hd__clkbuf_16
XFILLER_47_159 VGND VGND VPWR VPWR sky130_fd_sc_hd__decap_4
XFILLER_34_83 VGND VGND VPWR VPWR sky130_fd_sc_hd__fill_1
X_1023_ _0337_ _0350_ VGND VGND VPWR VPWR _0354_ sky130_fd_sc_hd__nand2_4
X_0807_ net77 net373 net84 _0172_ VGND VGND VPWR VPWR _0013_ sky130_fd_sc_hd__o211a_1
X_0738_ product_reg\[4\] net63 VGND VGND VPWR VPWR _0112_ sky130_fd_sc_hd__or2_1
XPHY_EDGE_ROW_2_Right_2 VGND VGND VPWR VPWR sky130_fd_sc_hd__decap_3
XFILLER_44_129 VGND VGND VPWR VPWR sky130_fd_sc_hd__fill_1
XFILLER_37_181 VGND VGND VPWR VPWR sky130_fd_sc_hd__fill_1
XFILLER_20_52 VPWR VGND VPWR VGND sky130_ef_sc_hd__decap_12
XFILLER_20_85 VPWR VGND VPWR VGND sky130_ef_sc_hd__decap_12
XFILLER_35_129 VPWR VGND VPWR VGND sky130_ef_sc_hd__decap_12
XFILLER_43_184 VPWR VGND VPWR VGND sky130_ef_sc_hd__decap_12
XTAP_TAPCELL_ROW_41_341 VGND VPWR sky130_fd_sc_hd__tapvpwrvgnd_1
XFILLER_31_302 VGND VGND VPWR VPWR sky130_fd_sc_hd__fill_1
Xrebuffer37 net165 VGND VGND VPWR VPWR net169 sky130_fd_sc_hd__dlygate4sd1_1
Xrebuffer15 _0396_ VGND VGND VPWR VPWR net147 sky130_fd_sc_hd__buf_2
XFILLER_34_173 VGND VGND VPWR VPWR sky130_fd_sc_hd__fill_2
Xrebuffer48 _0476_ VGND VGND VPWR VPWR net180 sky130_fd_sc_hd__buf_1
Xrebuffer26 _0103_ VGND VGND VPWR VPWR net158 sky130_fd_sc_hd__dlygate4sd1_1
X_1006_ _0325_ _0332_ _0333_ VGND VGND VPWR VPWR _0337_ sky130_fd_sc_hd__nand3_4
Xrebuffer105 _0511_ VGND VGND VPWR VPWR net237 sky130_fd_sc_hd__clkbuf_1
XFILLER_40_121 VGND VGND VPWR VPWR sky130_fd_sc_hd__fill_2
Xoutput40 net40 VGND VGND VPWR VPWR psum[12] sky130_fd_sc_hd__buf_2
Xoutput51 net51 VGND VGND VPWR VPWR psum[22] sky130_fd_sc_hd__buf_2
Xoutput62 net62 VGND VGND VPWR VPWR psum[3] sky130_fd_sc_hd__buf_2
XFILLER_48_265 VGND VGND VPWR VPWR sky130_fd_sc_hd__fill_1
XFILLER_31_110 VGND VGND VPWR VPWR sky130_fd_sc_hd__fill_2
XFILLER_31_143 VGND VGND VPWR VPWR sky130_fd_sc_hd__fill_2
XFILLER_31_132 VGND VGND VPWR VPWR sky130_fd_sc_hd__fill_2
XFILLER_16_195 VGND VGND VPWR VPWR sky130_fd_sc_hd__fill_1
XTAP_TAPCELL_ROW_52_403 VGND VPWR sky130_fd_sc_hd__tapvpwrvgnd_1
XFILLER_22_110 VGND VGND VPWR VPWR sky130_fd_sc_hd__decap_6
XFILLER_6_309 VGND VGND VPWR VPWR sky130_fd_sc_hd__fill_2
XFILLER_45_202 VGND VGND VPWR VPWR sky130_fd_sc_hd__decap_4
XFILLER_9_125 VGND VGND VPWR VPWR sky130_fd_sc_hd__decap_4
XFILLER_9_169 VGND VGND VPWR VPWR sky130_fd_sc_hd__decap_8
XFILLER_13_110 VGND VGND VPWR VPWR sky130_fd_sc_hd__fill_2
XFILLER_13_154 VPWR VGND VPWR VGND sky130_ef_sc_hd__decap_12
X_1340_ _0658_ _0663_ VGND VGND VPWR VPWR _0664_ sky130_fd_sc_hd__xnor2_1
XFILLER_47_7 VGND VGND VPWR VPWR sky130_fd_sc_hd__decap_8
Xrebuffer6 _0427_ VGND VGND VPWR VPWR net138 sky130_fd_sc_hd__clkbuf_2
X_1271_ _0596_ _0597_ _0570_ VGND VGND VPWR VPWR _0598_ sky130_fd_sc_hd__a21oi_1
XFILLER_3_55 VGND VGND VPWR VPWR sky130_fd_sc_hd__fill_1
XFILLER_51_249 VPWR VGND VPWR VGND sky130_ef_sc_hd__decap_12
X_0986_ _0316_ _0275_ VGND VGND VPWR VPWR _0318_ sky130_fd_sc_hd__nand2_2
XTAP_TAPCELL_ROW_14_193 VGND VPWR sky130_fd_sc_hd__tapvpwrvgnd_1
Xfanout115 net15 VGND VGND VPWR VPWR net115 sky130_fd_sc_hd__buf_2
Xfanout126 net127 VGND VGND VPWR VPWR net126 sky130_fd_sc_hd__buf_6
Xfanout104 net105 VGND VGND VPWR VPWR net104 sky130_fd_sc_hd__buf_4
XFILLER_47_39 VGND VGND VPWR VPWR sky130_fd_sc_hd__fill_1
XFILLER_27_279 VGND VGND VPWR VPWR sky130_fd_sc_hd__fill_1
XFILLER_5_3 VPWR VGND VPWR VGND sky130_ef_sc_hd__decap_12
XFILLER_10_179 VGND VGND VPWR VPWR sky130_fd_sc_hd__decap_4
XTAP_TAPCELL_ROW_11_174 VGND VPWR sky130_fd_sc_hd__tapvpwrvgnd_1
X_0771_ _0068_ _0071_ _0129_ _0123_ VGND VGND VPWR VPWR _0141_ sky130_fd_sc_hd__o211ai_2
X_0840_ _0200_ _0199_ net83 VGND VGND VPWR VPWR _0018_ sky130_fd_sc_hd__and3_1
X_1323_ _0646_ _0645_ VGND VGND VPWR VPWR _0648_ sky130_fd_sc_hd__and2b_1
XFILLER_38_3 VGND VGND VPWR VPWR sky130_fd_sc_hd__fill_1
X_1254_ _0578_ _0579_ _0576_ VGND VGND VPWR VPWR _0581_ sky130_fd_sc_hd__a21oi_1
X_1185_ _0442_ _0446_ _0379_ _0445_ VGND VGND VPWR VPWR _0514_ sky130_fd_sc_hd__o22ai_4
XTAP_TAPCELL_ROW_34_299 VGND VPWR sky130_fd_sc_hd__tapvpwrvgnd_1
XFILLER_32_293 VPWR VGND VPWR VGND sky130_ef_sc_hd__decap_12
XFILLER_24_238 VGND VGND VPWR VPWR sky130_fd_sc_hd__decap_4
X_0969_ net128 net102 net100 net88 VGND VGND VPWR VPWR _0301_ sky130_fd_sc_hd__a22o_1
XFILLER_2_197 VGND VGND VPWR VPWR sky130_fd_sc_hd__decap_4
XTAP_TAPCELL_ROW_16_200 VGND VPWR sky130_fd_sc_hd__tapvpwrvgnd_1
X_0823_ net77 net42 net85 _0186_ VGND VGND VPWR VPWR _0015_ sky130_fd_sc_hd__o211a_1
X_0754_ _0069_ _0072_ _0113_ _0110_ _0111_ VGND VGND VPWR VPWR _0126_ sky130_fd_sc_hd__o221ai_4
X_1306_ _0607_ _0609_ VGND VGND VPWR VPWR _0631_ sky130_fd_sc_hd__nand2_1
XFILLER_44_29 VGND VGND VPWR VPWR sky130_fd_sc_hd__decap_8
X_1099_ _0422_ _0425_ _0426_ VGND VGND VPWR VPWR _0429_ sky130_fd_sc_hd__a21oi_2
X_1237_ _0558_ _0560_ _0563_ _0000_ _0564_ VGND VGND VPWR VPWR _0565_ sky130_fd_sc_hd__o311a_1
X_1168_ _0392_ net139 _0430_ VGND VGND VPWR VPWR _0497_ sky130_fd_sc_hd__o21ai_2
XTAP_TAPCELL_ROW_30_280 VGND VPWR sky130_fd_sc_hd__tapvpwrvgnd_1
XTAP_TAPCELL_ROW_22_236 VGND VPWR sky130_fd_sc_hd__tapvpwrvgnd_1
XFILLER_18_85 VPWR VGND VPWR VGND sky130_ef_sc_hd__decap_12
XFILLER_50_94 VGND VGND VPWR VPWR sky130_fd_sc_hd__decap_3
XFILLER_50_83 VGND VGND VPWR VPWR sky130_fd_sc_hd__fill_1
XFILLER_11_252 VGND VGND VPWR VPWR sky130_fd_sc_hd__fill_1
XFILLER_46_193 VGND VGND VPWR VPWR sky130_fd_sc_hd__decap_3
X_1022_ _0337_ _0339_ _0344_ _0348_ VGND VGND VPWR VPWR _0353_ sky130_fd_sc_hd__o2bb2ai_2
X_0806_ _0170_ _0171_ _0070_ VGND VGND VPWR VPWR _0172_ sky130_fd_sc_hd__a21o_1
X_0737_ product_reg\[4\] net63 VGND VGND VPWR VPWR _0111_ sky130_fd_sc_hd__nand2_2
XFILLER_52_174 VGND VGND VPWR VPWR sky130_fd_sc_hd__decap_4
XFILLER_52_141 VGND VGND VPWR VPWR sky130_fd_sc_hd__fill_2
XTAP_TAPCELL_ROW_50_386 VGND VPWR sky130_fd_sc_hd__tapvpwrvgnd_1
XFILLER_20_97 VPWR VGND VPWR VGND sky130_ef_sc_hd__decap_12
XFILLER_43_152 VGND VGND VPWR VPWR sky130_fd_sc_hd__fill_1
XFILLER_35_119 VGND VGND VPWR VPWR sky130_fd_sc_hd__fill_1
XFILLER_43_196 VPWR VGND VPWR VGND sky130_ef_sc_hd__decap_12
Xrebuffer16 _0182_ VGND VGND VPWR VPWR net148 sky130_fd_sc_hd__dlymetal6s2s_1
Xrebuffer27 net160 VGND VGND VPWR VPWR net159 sky130_fd_sc_hd__dlygate4sd1_1
XPHY_EDGE_ROW_16_Left_69 VGND VGND VPWR VPWR sky130_fd_sc_hd__decap_3
XFILLER_20_3 VGND VGND VPWR VPWR sky130_fd_sc_hd__fill_1
Xrebuffer38 _0182_ VGND VGND VPWR VPWR net170 sky130_fd_sc_hd__dlymetal6s2s_1
XFILLER_34_141 VPWR VGND VPWR VGND sky130_ef_sc_hd__decap_12
X_1005_ net153 _0335_ _0334_ VGND VGND VPWR VPWR _0336_ sky130_fd_sc_hd__o21ai_1
Xrebuffer49 _0437_ VGND VGND VPWR VPWR net181 sky130_fd_sc_hd__clkbuf_2
Xrebuffer106 _0511_ VGND VGND VPWR VPWR net238 sky130_fd_sc_hd__buf_2
Xrebuffer128 _0504_ VGND VGND VPWR VPWR net260 sky130_fd_sc_hd__dlymetal6s2s_1
XFILLER_17_108 VGND VGND VPWR VPWR sky130_fd_sc_hd__decap_4
XFILLER_40_188 VGND VGND VPWR VPWR sky130_fd_sc_hd__fill_1
Xoutput41 net41 VGND VGND VPWR VPWR psum[13] sky130_fd_sc_hd__buf_2
Xoutput52 net52 VGND VGND VPWR VPWR psum[23] sky130_fd_sc_hd__buf_2
Xoutput30 net30 VGND VGND VPWR VPWR b_out[1] sky130_fd_sc_hd__buf_2
Xoutput63 net63 VGND VGND VPWR VPWR psum[4] sky130_fd_sc_hd__buf_2
XFILLER_16_141 VGND VGND VPWR VPWR sky130_fd_sc_hd__fill_1
.ends
